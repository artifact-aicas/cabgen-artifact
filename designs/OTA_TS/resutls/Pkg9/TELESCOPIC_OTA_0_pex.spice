* NGSPICE file created from TELESCOPIC_OTA_0.ext - technology: sky130A

.subckt NMOS_4T_28886488_X2_Y1_1774869527 a_230_357# a_200_252# a_147_357# a_241_1232#
X0 a_230_357# a_200_252# a_147_357# a_241_1232# sky130_fd_pr__nfet_01v8 ad=0.294 pd=2.38 as=0.5565 ps=4.73 w=2.1 l=0.15
X1 a_147_357# a_200_252# a_230_357# a_241_1232# sky130_fd_pr__nfet_01v8 ad=0.294 pd=2.38 as=0.294 ps=2.38 w=2.1 l=0.15
X2 a_230_357# a_200_252# a_147_357# a_241_1232# sky130_fd_pr__nfet_01v8 ad=0.294 pd=2.38 as=0.294 ps=2.38 w=2.1 l=0.15
X3 a_147_357# a_200_252# a_230_357# a_241_1232# sky130_fd_pr__nfet_01v8 ad=0.5565 pd=4.73 as=0.294 ps=2.38 w=2.1 l=0.15
C0 a_230_357# a_147_357# 1.34953f
C1 a_147_357# a_200_252# 0.148792f
C2 a_230_357# a_200_252# 0.157436f
C3 a_230_357# a_241_1232# 0.138317f
C4 a_147_357# a_241_1232# 0.472118f
C5 a_200_252# a_241_1232# 0.796798f
.ends

.subckt PMOS_S_89697479_X1_Y2_1774869529 a_230_357# a_200_252# w_0_0# VSUBS
X0 a_230_357# a_200_252# w_0_0# w_0_0# sky130_fd_pr__pfet_01v8 ad=0.294 pd=2.38 as=0.5565 ps=4.73 w=2.1 l=0.15
X1 w_0_0# a_200_252# a_230_357# w_0_0# sky130_fd_pr__pfet_01v8 ad=0.5565 pd=4.73 as=0.294 ps=2.38 w=2.1 l=0.15
X2 a_230_357# a_200_252# w_0_0# w_0_0# sky130_fd_pr__pfet_01v8 ad=0.294 pd=2.38 as=0.5565 ps=4.73 w=2.1 l=0.15
X3 w_0_0# a_200_252# a_230_357# w_0_0# sky130_fd_pr__pfet_01v8 ad=0.5565 pd=4.73 as=0.294 ps=2.38 w=2.1 l=0.15
C0 a_230_357# a_200_252# 0.563131f
C1 a_200_252# w_0_0# 1.72728f
C2 a_230_357# w_0_0# 1.90094f
C3 a_230_357# VSUBS 0.307398f
C4 a_200_252# VSUBS 0.421954f
C5 w_0_0# VSUBS 5.03737f
.ends

.subckt PMOS_4T_8744924_X3_Y2_1774869528 a_230_357# a_200_252# a_147_357# w_0_0# VSUBS
X0 a_230_357# a_200_252# a_147_357# w_0_0# sky130_fd_pr__pfet_01v8 ad=0.294 pd=2.38 as=0.5565 ps=4.73 w=2.1 l=0.15
X1 a_147_357# a_200_252# a_230_357# w_0_0# sky130_fd_pr__pfet_01v8 ad=0.294 pd=2.38 as=0.294 ps=2.38 w=2.1 l=0.15
X2 a_147_357# a_200_252# a_230_357# w_0_0# sky130_fd_pr__pfet_01v8 ad=0.5565 pd=4.73 as=0.294 ps=2.38 w=2.1 l=0.15
X3 a_230_357# a_200_252# a_147_357# w_0_0# sky130_fd_pr__pfet_01v8 ad=0.294 pd=2.38 as=0.294 ps=2.38 w=2.1 l=0.15
X4 a_147_357# a_200_252# a_230_357# w_0_0# sky130_fd_pr__pfet_01v8 ad=0.294 pd=2.38 as=0.294 ps=2.38 w=2.1 l=0.15
X5 a_230_357# a_200_252# a_147_357# w_0_0# sky130_fd_pr__pfet_01v8 ad=0.294 pd=2.38 as=0.5565 ps=4.73 w=2.1 l=0.15
X6 a_147_357# a_200_252# a_230_357# w_0_0# sky130_fd_pr__pfet_01v8 ad=0.294 pd=2.38 as=0.294 ps=2.38 w=2.1 l=0.15
X7 a_230_357# a_200_252# a_147_357# w_0_0# sky130_fd_pr__pfet_01v8 ad=0.294 pd=2.38 as=0.294 ps=2.38 w=2.1 l=0.15
X8 a_147_357# a_200_252# a_230_357# w_0_0# sky130_fd_pr__pfet_01v8 ad=0.294 pd=2.38 as=0.294 ps=2.38 w=2.1 l=0.15
X9 a_147_357# a_200_252# a_230_357# w_0_0# sky130_fd_pr__pfet_01v8 ad=0.5565 pd=4.73 as=0.294 ps=2.38 w=2.1 l=0.15
X10 a_230_357# a_200_252# a_147_357# w_0_0# sky130_fd_pr__pfet_01v8 ad=0.294 pd=2.38 as=0.294 ps=2.38 w=2.1 l=0.15
X11 a_230_357# a_200_252# a_147_357# w_0_0# sky130_fd_pr__pfet_01v8 ad=0.294 pd=2.38 as=0.294 ps=2.38 w=2.1 l=0.15
C0 a_147_357# a_200_252# 0.914881f
C1 a_200_252# w_0_0# 1.77699f
C2 a_230_357# a_200_252# 0.956186f
C3 a_147_357# w_0_0# 0.568109f
C4 a_147_357# a_230_357# 4.52833f
C5 a_230_357# w_0_0# 0.268675f
C6 a_230_357# VSUBS 0.310557f
C7 a_147_357# VSUBS 0.633587f
C8 a_200_252# VSUBS 0.618746f
C9 w_0_0# VSUBS 7.07009f
.ends

.subckt SCM_NMOS_72619132_X7_Y1_1774869530 a_200_252# a_402_357# a_147_357#
X0 a_200_252# a_200_252# a_147_357# a_147_357# sky130_fd_pr__nfet_01v8 ad=0.294 pd=2.38 as=0.294 ps=2.38 w=2.1 l=0.15
X1 a_147_357# a_200_252# a_402_357# a_147_357# sky130_fd_pr__nfet_01v8 ad=0.294 pd=2.38 as=0.294 ps=2.38 w=2.1 l=0.15
X2 a_147_357# a_200_252# a_402_357# a_147_357# sky130_fd_pr__nfet_01v8 ad=0.5565 pd=4.73 as=0.294 ps=2.38 w=2.1 l=0.15
X3 a_147_357# a_200_252# a_200_252# a_147_357# sky130_fd_pr__nfet_01v8 ad=0.294 pd=2.38 as=0.294 ps=2.38 w=2.1 l=0.15
X4 a_147_357# a_200_252# a_200_252# a_147_357# sky130_fd_pr__nfet_01v8 ad=0.294 pd=2.38 as=0.294 ps=2.38 w=2.1 l=0.15
X5 a_200_252# a_200_252# a_147_357# a_147_357# sky130_fd_pr__nfet_01v8 ad=0.294 pd=2.38 as=0.5565 ps=4.73 w=2.1 l=0.15
X6 a_147_357# a_200_252# a_200_252# a_147_357# sky130_fd_pr__nfet_01v8 ad=0.294 pd=2.38 as=0.294 ps=2.38 w=2.1 l=0.15
X7 a_402_357# a_200_252# a_147_357# a_147_357# sky130_fd_pr__nfet_01v8 ad=0.294 pd=2.38 as=0.294 ps=2.38 w=2.1 l=0.15
X8 a_147_357# a_200_252# a_200_252# a_147_357# sky130_fd_pr__nfet_01v8 ad=0.294 pd=2.38 as=0.294 ps=2.38 w=2.1 l=0.15
X9 a_200_252# a_200_252# a_147_357# a_147_357# sky130_fd_pr__nfet_01v8 ad=0.294 pd=2.38 as=0.294 ps=2.38 w=2.1 l=0.15
X10 a_402_357# a_200_252# a_147_357# a_147_357# sky130_fd_pr__nfet_01v8 ad=0.294 pd=2.38 as=0.294 ps=2.38 w=2.1 l=0.15
X11 a_402_357# a_200_252# a_147_357# a_147_357# sky130_fd_pr__nfet_01v8 ad=0.294 pd=2.38 as=0.294 ps=2.38 w=2.1 l=0.15
X12 a_147_357# a_200_252# a_402_357# a_147_357# sky130_fd_pr__nfet_01v8 ad=0.294 pd=2.38 as=0.294 ps=2.38 w=2.1 l=0.15
X13 a_402_357# a_200_252# a_147_357# a_147_357# sky130_fd_pr__nfet_01v8 ad=0.294 pd=2.38 as=0.294 ps=2.38 w=2.1 l=0.15
X14 a_147_357# a_200_252# a_402_357# a_147_357# sky130_fd_pr__nfet_01v8 ad=0.294 pd=2.38 as=0.294 ps=2.38 w=2.1 l=0.15
X15 a_147_357# a_200_252# a_200_252# a_147_357# sky130_fd_pr__nfet_01v8 ad=0.294 pd=2.38 as=0.294 ps=2.38 w=2.1 l=0.15
X16 a_402_357# a_200_252# a_147_357# a_147_357# sky130_fd_pr__nfet_01v8 ad=0.294 pd=2.38 as=0.294 ps=2.38 w=2.1 l=0.15
X17 a_147_357# a_200_252# a_402_357# a_147_357# sky130_fd_pr__nfet_01v8 ad=0.294 pd=2.38 as=0.294 ps=2.38 w=2.1 l=0.15
X18 a_200_252# a_200_252# a_147_357# a_147_357# sky130_fd_pr__nfet_01v8 ad=0.294 pd=2.38 as=0.294 ps=2.38 w=2.1 l=0.15
X19 a_200_252# a_200_252# a_147_357# a_147_357# sky130_fd_pr__nfet_01v8 ad=0.294 pd=2.38 as=0.294 ps=2.38 w=2.1 l=0.15
X20 a_147_357# a_200_252# a_200_252# a_147_357# sky130_fd_pr__nfet_01v8 ad=0.294 pd=2.38 as=0.294 ps=2.38 w=2.1 l=0.15
X21 a_402_357# a_200_252# a_147_357# a_147_357# sky130_fd_pr__nfet_01v8 ad=0.294 pd=2.38 as=0.294 ps=2.38 w=2.1 l=0.15
X22 a_147_357# a_200_252# a_402_357# a_147_357# sky130_fd_pr__nfet_01v8 ad=0.294 pd=2.38 as=0.294 ps=2.38 w=2.1 l=0.15
X23 a_402_357# a_200_252# a_147_357# a_147_357# sky130_fd_pr__nfet_01v8 ad=0.294 pd=2.38 as=0.294 ps=2.38 w=2.1 l=0.15
X24 a_147_357# a_200_252# a_402_357# a_147_357# sky130_fd_pr__nfet_01v8 ad=0.294 pd=2.38 as=0.294 ps=2.38 w=2.1 l=0.15
X25 a_200_252# a_200_252# a_147_357# a_147_357# sky130_fd_pr__nfet_01v8 ad=0.294 pd=2.38 as=0.294 ps=2.38 w=2.1 l=0.15
X26 a_200_252# a_200_252# a_147_357# a_147_357# sky130_fd_pr__nfet_01v8 ad=0.294 pd=2.38 as=0.294 ps=2.38 w=2.1 l=0.15
X27 a_147_357# a_200_252# a_200_252# a_147_357# sky130_fd_pr__nfet_01v8 ad=0.294 pd=2.38 as=0.294 ps=2.38 w=2.1 l=0.15
C0 a_402_357# a_200_252# 1.93269f
C1 a_402_357# a_147_357# 5.97736f
C2 a_200_252# a_147_357# 11.444099f
.ends

.subckt TELESCOPIC_OTA_0 IB VCN VOUT VIP VIN VCP VSS VDD
XNMOS_4T_28886488_X2_Y1_1774869527_2 VOUT VCN m1_1860_2828# VSS NMOS_4T_28886488_X2_Y1_1774869527
XNMOS_4T_28886488_X2_Y1_1774869527_3 m2_230_1727# VCN m1_430_2744# VSS NMOS_4T_28886488_X2_Y1_1774869527
XPMOS_S_89697479_X1_Y2_1774869529_0 m1_312_1904# m2_230_1727# VDD VSS PMOS_S_89697479_X1_Y2_1774869529
XPMOS_S_89697479_X1_Y2_1774869529_1 m1_1860_1904# m2_230_1727# VDD VSS PMOS_S_89697479_X1_Y2_1774869529
XPMOS_4T_8744924_X3_Y2_1774869528_1 m2_230_1727# VCP m1_1860_1904# VDD VSS PMOS_4T_8744924_X3_Y2_1774869528
XPMOS_4T_8744924_X3_Y2_1774869528_0 VOUT VCP m1_312_1904# VDD VSS PMOS_4T_8744924_X3_Y2_1774869528
XSCM_NMOS_72619132_X7_Y1_1774869530_0 IB li_663_2839# VSS SCM_NMOS_72619132_X7_Y1_1774869530
XNMOS_4T_28886488_X2_Y1_1774869527_0 m1_1860_2828# VIN li_663_2839# VSS NMOS_4T_28886488_X2_Y1_1774869527
XNMOS_4T_28886488_X2_Y1_1774869527_1 m1_430_2744# VIP li_663_2839# VSS NMOS_4T_28886488_X2_Y1_1774869527
R0 VCN.n5 VCN.t4 568.582
R1 VCN.n5 VCN.t5 568.582
R2 VCN.n3 VCN.t6 568.582
R3 VCN.n3 VCN.t7 568.582
R4 VCN.n1 VCN.t3 568.582
R5 VCN.n1 VCN.t2 568.582
R6 VCN.n0 VCN.t1 568.582
R7 VCN.n0 VCN.t0 568.582
R8 VCN.n2 VCN.n0 161.685
R9 VCN VCN.n5 161.493
R10 VCN.n4 VCN.n3 161.3
R11 VCN.n2 VCN.n1 161.3
R12 VCN.n4 VCN.n2 1.15229
R13 VCN VCN.n4 0.192464
R14 VDD.n3 VDD.n1 1438.57
R15 VDD.n6 VDD.n4 1438.57
R16 VDD.n3 VDD.n2 1438.19
R17 VDD.n6 VDD.n5 1438.18
R18 VDD.n9 VDD 618.905
R19 VDD.n18 VDD.n17 383.993
R20 VDD.n10 VDD.n9 287.168
R21 VDD.n9 VDD.n8 111.936
R22 VDD.n10 VDD.n0 111.936
R23 VDD.n11 VDD.n10 97.9391
R24 VDD.n12 VDD.n11 30.3948
R25 VDD.n13 VDD.n12 30.3948
R26 VDD.n14 VDD.n13 30.3948
R27 VDD.n15 VDD.n14 30.3948
R28 VDD.n17 VDD.n15 15.1977
R29 VDD.n17 VDD.n16 15.1977
R30 VDD VDD.n8 13.1363
R31 VDD.n19 VDD.n18 12.9775
R32 VDD.n7 VDD.n3 7.1255
R33 VDD.n7 VDD.n6 4.5005
R34 VDD VDD.n19 3.96272
R35 VDD.n18 VDD.n7 2.6255
R36 VDD.n8 VDD.n0 0.253125
R37 VDD.n19 VDD.n0 0.2026
R38 VCP.n2 VCP.t23 568.582
R39 VCP.n2 VCP.t14 568.582
R40 VCP.n1 VCP.t15 568.582
R41 VCP.n1 VCP.t20 568.582
R42 VCP.n0 VCP.t12 568.582
R43 VCP.n0 VCP.t13 568.582
R44 VCP.n15 VCP.t19 568.582
R45 VCP.n15 VCP.t21 568.582
R46 VCP.n14 VCP.t22 568.582
R47 VCP.n14 VCP.t16 568.582
R48 VCP.n13 VCP.t17 568.582
R49 VCP.n13 VCP.t18 568.582
R50 VCP.n6 VCP.t1 568.582
R51 VCP.n6 VCP.t0 568.582
R52 VCP.n5 VCP.t8 568.582
R53 VCP.n5 VCP.t3 568.582
R54 VCP.n4 VCP.t2 568.582
R55 VCP.n4 VCP.t11 568.582
R56 VCP.n10 VCP.t6 568.582
R57 VCP.n10 VCP.t5 568.582
R58 VCP.n9 VCP.t4 568.582
R59 VCP.n9 VCP.t10 568.582
R60 VCP.n8 VCP.t9 568.582
R61 VCP.n8 VCP.t7 568.582
R62 VCP.n3 VCP.n2 161.685
R63 VCP.n3 VCP.n0 161.685
R64 VCP.n16 VCP.n15 161.685
R65 VCP.n16 VCP.n13 161.685
R66 VCP.n7 VCP.n6 161.685
R67 VCP.n7 VCP.n4 161.685
R68 VCP.n11 VCP.n10 161.685
R69 VCP.n11 VCP.n8 161.685
R70 VCP.n3 VCP.n1 161.3
R71 VCP.n16 VCP.n14 161.3
R72 VCP.n7 VCP.n5 161.3
R73 VCP.n11 VCP.n9 161.3
R74 VCP VCP.n12 10.9201
R75 VCP.n12 VCP.n7 5.813
R76 VCP.n12 VCP.n11 5.813
R77 VCP VCP.n3 5.813
R78 VCP VCP.n16 5.813
R79 IB.n14 IB.t20 568.582
R80 IB.n14 IB.t18 568.582
R81 IB.n15 IB.t34 568.582
R82 IB.n15 IB.t39 568.582
R83 IB.n17 IB.t26 568.582
R84 IB.n17 IB.t16 568.582
R85 IB.n19 IB.t36 568.582
R86 IB.n19 IB.t41 568.582
R87 IB.n21 IB.t4 568.582
R88 IB.n21 IB.t24 568.582
R89 IB.n23 IB.t31 568.582
R90 IB.n23 IB.t37 568.582
R91 IB.n13 IB.t2 568.582
R92 IB.n13 IB.t22 568.582
R93 IB.n11 IB.t32 568.582
R94 IB.n11 IB.t33 568.582
R95 IB.n9 IB.t10 568.582
R96 IB.n9 IB.t0 568.582
R97 IB.n7 IB.t30 568.582
R98 IB.n7 IB.t35 568.582
R99 IB.n5 IB.t8 568.582
R100 IB.n5 IB.t6 568.582
R101 IB.n3 IB.t38 568.582
R102 IB.n3 IB.t28 568.582
R103 IB.n1 IB.t14 568.582
R104 IB.n1 IB.t12 568.582
R105 IB.n0 IB.t40 568.582
R106 IB.n0 IB.t29 568.582
R107 IB.n16 IB.n14 161.685
R108 IB.n2 IB.n0 161.685
R109 IB.n16 IB.n15 161.3
R110 IB.n18 IB.n17 161.3
R111 IB.n20 IB.n19 161.3
R112 IB.n22 IB.n21 161.3
R113 IB.n24 IB.n23 161.3
R114 IB.n25 IB.n13 161.3
R115 IB.n12 IB.n11 161.3
R116 IB.n10 IB.n9 161.3
R117 IB.n8 IB.n7 161.3
R118 IB.n6 IB.n5 161.3
R119 IB.n4 IB.n3 161.3
R120 IB.n2 IB.n1 161.3
R121 IB.n34 IB.n32 142.79
R122 IB.n28 IB.n26 142.79
R123 IB.n34 IB.n33 142.023
R124 IB.n36 IB.n35 142.023
R125 IB.n37 IB.n31 142.023
R126 IB.n30 IB.n29 142.023
R127 IB.n28 IB.n27 142.023
R128 IB.n32 IB.t19 8.0005
R129 IB.n32 IB.t21 8.0005
R130 IB.n33 IB.t17 8.0005
R131 IB.n33 IB.t27 8.0005
R132 IB.n35 IB.t25 8.0005
R133 IB.n35 IB.t5 8.0005
R134 IB.n31 IB.t23 8.0005
R135 IB.n31 IB.t3 8.0005
R136 IB.n29 IB.t1 8.0005
R137 IB.n29 IB.t11 8.0005
R138 IB.n27 IB.t7 8.0005
R139 IB.n27 IB.t9 8.0005
R140 IB.n26 IB.t13 8.0005
R141 IB.n26 IB.t15 8.0005
R142 IB IB.n25 5.438
R143 IB IB.n37 5.438
R144 IB.n30 IB.n28 0.768357
R145 IB.n37 IB.n30 0.768357
R146 IB.n37 IB.n36 0.768357
R147 IB.n36 IB.n34 0.768357
R148 IB.n4 IB.n2 0.384429
R149 IB.n6 IB.n4 0.384429
R150 IB.n8 IB.n6 0.384429
R151 IB.n10 IB.n8 0.384429
R152 IB.n12 IB.n10 0.384429
R153 IB.n25 IB.n12 0.384429
R154 IB.n25 IB.n24 0.384429
R155 IB.n24 IB.n22 0.384429
R156 IB.n22 IB.n20 0.384429
R157 IB.n20 IB.n18 0.384429
R158 IB.n18 IB.n16 0.384429
R159 VIN.n1 VIN.t0 568.582
R160 VIN.n1 VIN.t1 568.582
R161 VIN.n0 VIN.t2 568.582
R162 VIN.n0 VIN.t3 568.582
R163 VIN VIN.n1 161.493
R164 VIN VIN.n0 161.493
R165 VIP.n1 VIP.t3 568.582
R166 VIP.n1 VIP.t2 568.582
R167 VIP.n0 VIP.t1 568.582
R168 VIP.n0 VIP.t0 568.582
R169 VIP VIP.n1 161.493
R170 VIP VIP.n0 161.493
C0 VDD li_663_2839# 0.381941f
C1 m1_312_1904# m2_230_1727# 0.339988f
C2 VOUT m1_1860_1904# 0.067401f
C3 VDD m1_312_1904# 0.524219f
C4 m1_1860_2828# VIN 5.04e-19
C5 m1_1860_2828# m1_1860_1904# 0.164097f
C6 VIN VCN 0.027605f
C7 IB VIN 0.00472f
C8 VCP li_663_2839# 7.15e-19
C9 VIN m2_230_1727# 0.005506f
C10 m1_1860_1904# VCN 3.6e-19
C11 m1_1860_1904# m2_230_1727# 0.393998f
C12 VDD VIN 0.074506f
C13 VOUT m1_430_2744# 0.084381f
C14 m1_312_1904# VCP 0.200544f
C15 VDD m1_1860_1904# 0.470182f
C16 VOUT m1_1860_2828# 0.089584f
C17 m1_1860_2828# m1_430_2744# 0.079353f
C18 m1_312_1904# li_663_2839# 0.011077f
C19 m1_430_2744# VIP 5.04e-19
C20 m1_430_2744# VCN -0.026008f
C21 VOUT VCN 0.00783f
C22 IB VOUT 2.28e-20
C23 IB m1_430_2744# 5.35e-19
C24 VOUT m2_230_1727# 0.757448f
C25 m1_430_2744# m2_230_1727# 0.09722f
C26 m1_1860_1904# VCP 0.200544f
C27 VDD m1_430_2744# 0.130774f
C28 m1_1860_2828# VCN -0.026008f
C29 VOUT VDD 0.219064f
C30 IB m1_1860_2828# 5.55e-19
C31 VIN li_663_2839# 0.006361f
C32 m1_1860_2828# m2_230_1727# 0.091362f
C33 m1_1860_1904# li_663_2839# 0.013257f
C34 VCN VIP 0.027605f
C35 IB VIP 0.00483f
C36 m1_1860_2828# VDD 0.118232f
C37 m2_230_1727# VIP 0.005506f
C38 IB VCN 0.039586f
C39 m1_1860_1904# m1_312_1904# 0.129954f
C40 m2_230_1727# VCN 0.00681f
C41 IB m2_230_1727# 4.78e-20
C42 VDD VIP 0.086358f
C43 VDD VCN 0.177303f
C44 IB VDD 0.122079f
C45 VOUT VCP 0.082871f
C46 VCP m1_430_2744# 0.005872f
C47 VDD m2_230_1727# 0.765246f
C48 m1_1860_2828# VCP 0.008418f
C49 VOUT li_663_2839# 0.088929f
C50 li_663_2839# m1_430_2744# 0.654743f
C51 m1_1860_1904# VIN 6.16e-19
C52 VOUT m1_312_1904# 0.068643f
C53 m1_312_1904# m1_430_2744# 0.152143f
C54 m1_1860_2828# li_663_2839# 0.647574f
C55 VCP VCN 0.007619f
C56 VCP m2_230_1727# 0.628707f
C57 li_663_2839# VIP 0.006286f
C58 VDD VCP 0.449472f
C59 li_663_2839# VCN 0.231782f
C60 IB li_663_2839# 0.135167f
C61 li_663_2839# m2_230_1727# 0.164218f
C62 m1_312_1904# VIP 6.16e-19
C63 m1_312_1904# VCN 3.6e-19
C64 VOUT VSS 4.786625f
C65 m2_230_1727# VSS 1.208794f
C66 IB.t29 VSS 0.013783f
C67 IB.t40 VSS 0.013783f
C68 IB.n0 VSS 0.025501f
C69 IB.t12 VSS 0.013783f
C70 IB.t14 VSS 0.013783f
C71 IB.n1 VSS 0.025439f
C72 IB.n2 VSS 0.056871f
C73 IB.t28 VSS 0.013783f
C74 IB.t38 VSS 0.013783f
C75 IB.n3 VSS 0.025439f
C76 IB.n4 VSS 0.030809f
C77 IB.t6 VSS 0.013783f
C78 IB.t8 VSS 0.013783f
C79 IB.n5 VSS 0.025439f
C80 IB.n6 VSS 0.030809f
C81 IB.t35 VSS 0.013783f
C82 IB.t30 VSS 0.013783f
C83 IB.n7 VSS 0.025439f
C84 IB.n8 VSS 0.030809f
C85 IB.t0 VSS 0.013783f
C86 IB.t10 VSS 0.013783f
C87 IB.n9 VSS 0.025439f
C88 IB.n10 VSS 0.030809f
C89 IB.t33 VSS 0.013783f
C90 IB.t32 VSS 0.013783f
C91 IB.n11 VSS 0.025439f
C92 IB.n12 VSS 0.030809f
C93 IB.t22 VSS 0.013783f
C94 IB.t2 VSS 0.013783f
C95 IB.n13 VSS 0.025439f
C96 IB.t18 VSS 0.013783f
C97 IB.t20 VSS 0.013783f
C98 IB.n14 VSS 0.025501f
C99 IB.t39 VSS 0.013783f
C100 IB.t34 VSS 0.013783f
C101 IB.n15 VSS 0.025439f
C102 IB.n16 VSS 0.056871f
C103 IB.t16 VSS 0.013783f
C104 IB.t26 VSS 0.013783f
C105 IB.n17 VSS 0.025439f
C106 IB.n18 VSS 0.030809f
C107 IB.t41 VSS 0.013783f
C108 IB.t36 VSS 0.013783f
C109 IB.n19 VSS 0.025439f
C110 IB.n20 VSS 0.030809f
C111 IB.t24 VSS 0.013783f
C112 IB.t4 VSS 0.013783f
C113 IB.n21 VSS 0.025439f
C114 IB.n22 VSS 0.030809f
C115 IB.t37 VSS 0.013783f
C116 IB.t31 VSS 0.013783f
C117 IB.n23 VSS 0.025439f
C118 IB.n24 VSS 0.030809f
C119 IB.n25 VSS 0.034568f
C120 IB.t13 VSS 0.00946f
C121 IB.t15 VSS 0.00946f
C122 IB.n26 VSS 0.051234f
C123 IB.t7 VSS 0.00946f
C124 IB.t9 VSS 0.00946f
C125 IB.n27 VSS 0.051001f
C126 IB.n28 VSS 0.098743f
C127 IB.t1 VSS 0.00946f
C128 IB.t11 VSS 0.00946f
C129 IB.n29 VSS 0.051001f
C130 IB.n30 VSS 0.055705f
C131 IB.t23 VSS 0.00946f
C132 IB.t3 VSS 0.00946f
C133 IB.n31 VSS 0.051001f
C134 IB.t19 VSS 0.00946f
C135 IB.t21 VSS 0.00946f
C136 IB.n32 VSS 0.051234f
C137 IB.t17 VSS 0.00946f
C138 IB.t27 VSS 0.00946f
C139 IB.n33 VSS 0.051001f
C140 IB.n34 VSS 0.098743f
C141 IB.t25 VSS 0.00946f
C142 IB.t5 VSS 0.00946f
C143 IB.n35 VSS 0.051001f
C144 IB.n36 VSS 0.055705f
C145 IB.n37 VSS 0.059464f
C146 VCP.t12 VSS 0.043242f
C147 VCP.t13 VSS 0.043242f
C148 VCP.n0 VSS 0.080005f
C149 VCP.t15 VSS 0.043242f
C150 VCP.t20 VSS 0.043242f
C151 VCP.n1 VSS 0.07981f
C152 VCP.t23 VSS 0.043242f
C153 VCP.t14 VSS 0.043242f
C154 VCP.n2 VSS 0.080005f
C155 VCP.n3 VSS 0.280992f
C156 VCP.t2 VSS 0.043242f
C157 VCP.t11 VSS 0.043242f
C158 VCP.n4 VSS 0.080005f
C159 VCP.t8 VSS 0.043242f
C160 VCP.t3 VSS 0.043242f
C161 VCP.n5 VSS 0.07981f
C162 VCP.t1 VSS 0.043242f
C163 VCP.t0 VSS 0.043242f
C164 VCP.n6 VSS 0.080005f
C165 VCP.n7 VSS 0.280992f
C166 VCP.t9 VSS 0.043242f
C167 VCP.t7 VSS 0.043242f
C168 VCP.n8 VSS 0.080005f
C169 VCP.t4 VSS 0.043242f
C170 VCP.t10 VSS 0.043242f
C171 VCP.n9 VSS 0.07981f
C172 VCP.t6 VSS 0.043242f
C173 VCP.t5 VSS 0.043242f
C174 VCP.n10 VSS 0.080005f
C175 VCP.n11 VSS 0.280992f
C176 VCP.n12 VSS 0.439468f
C177 VCP.t17 VSS 0.043242f
C178 VCP.t18 VSS 0.043242f
C179 VCP.n13 VSS 0.080005f
C180 VCP.t22 VSS 0.043242f
C181 VCP.t16 VSS 0.043242f
C182 VCP.n14 VSS 0.07981f
C183 VCP.t19 VSS 0.043242f
C184 VCP.t21 VSS 0.043242f
C185 VCP.n15 VSS 0.080005f
C186 VCP.n16 VSS 0.280992f
C187 VDD.n0 VSS 0.261197f
C188 VDD.n1 VSS 0.006647f
C189 VDD.n2 VSS 0.006623f
C190 VDD.n3 VSS 0.197664f
C191 VDD.n4 VSS 0.006647f
C192 VDD.n5 VSS 0.006623f
C193 VDD.n6 VSS 0.178576f
C194 VDD.n7 VSS 0.131f
C195 VDD.n8 VSS 0.475216f
C196 VDD.n9 VSS 4.58588f
C197 VDD.n10 VSS 2.22635f
C198 VDD.n11 VSS 0.866697f
C199 VDD.n12 VSS 0.34497f
C200 VDD.n13 VSS 0.34497f
C201 VDD.n14 VSS 0.34497f
C202 VDD.n15 VSS 0.258727f
C203 VDD.n16 VSS 0.948667f
C204 VDD.n17 VSS 0.167386f
C205 VDD.n18 VSS 0.098968f
C206 VDD.n19 VSS 0.203125f
C207 m1_430_2744# VSS 0.436903f
C208 VIP VSS 0.757208f
C209 m1_1860_2828# VSS 0.497272f
C210 li_663_2839# VSS 7.7829f
C211 VIN VSS 0.791224f
C212 IB VSS 12.745866f
C213 m1_312_1904# VSS 0.038201f
C214 VCP VSS 0.975651f
C215 VDD VSS 29.010654f
C216 m1_1860_1904# VSS 0.192288f
C217 VCN VSS 1.56594f
.ends
