* NGSPICE file created from TELESCOPIC_OTA_0.ext - technology: sky130A

.subckt NMOS_4T_28886488_X2_Y1_1774869527 a_230_357# a_200_252# a_147_357# a_241_1232#
X0 a_230_357# a_200_252# a_147_357# a_241_1232# sky130_fd_pr__nfet_01v8 ad=0.294 pd=2.38 as=0.5565 ps=4.73 w=2.1 l=0.15 M=4
.ends

.subckt PMOS_S_89697479_X1_Y2_1774869529 a_230_357# a_200_252# w_0_0#
X0 a_230_357# a_200_252# w_0_0# w_0_0# sky130_fd_pr__pfet_01v8 ad=0.294 pd=2.38 as=0.5565 ps=4.73 w=2.1 l=0.15 M=4
.ends

.subckt PMOS_4T_8744924_X3_Y2_1774869528 a_230_357# a_200_252# a_147_357# w_0_0#
X0 a_230_357# a_200_252# a_147_357# w_0_0# sky130_fd_pr__pfet_01v8 ad=0.294 pd=2.38 as=0.5565 ps=4.73 w=2.1 l=0.15 M=12
.ends

.subckt SCM_NMOS_72619132_X7_Y1_1774869530 a_200_252# a_402_357# a_147_357#
X0 a_200_252# a_200_252# a_147_357# a_147_357# sky130_fd_pr__nfet_01v8 ad=0.294 pd=2.38 as=0.294 ps=2.38 w=2.1 l=0.15 M=14
X1 a_147_357# a_200_252# a_402_357# a_147_357# sky130_fd_pr__nfet_01v8 ad=0.294 pd=2.38 as=0.294 ps=2.38 w=2.1 l=0.15 M=14
.ends

.subckt TELESCOPIC_OTA_0 IB VCN VOUT VIP VIN VCP VSS VDD
XNMOS_4T_28886488_X2_Y1_1774869527_2 VOUT VCN m1_1860_2828# VSS NMOS_4T_28886488_X2_Y1_1774869527
XNMOS_4T_28886488_X2_Y1_1774869527_3 m2_230_1727# VCN m1_430_2744# VSS NMOS_4T_28886488_X2_Y1_1774869527
XPMOS_S_89697479_X1_Y2_1774869529_0 m1_312_1904# m2_230_1727# VDD PMOS_S_89697479_X1_Y2_1774869529
XPMOS_S_89697479_X1_Y2_1774869529_1 m1_1860_1904# m2_230_1727# VDD PMOS_S_89697479_X1_Y2_1774869529
XPMOS_4T_8744924_X3_Y2_1774869528_1 m2_230_1727# VCP m1_1860_1904# VDD PMOS_4T_8744924_X3_Y2_1774869528
XPMOS_4T_8744924_X3_Y2_1774869528_0 VOUT VCP m1_312_1904# VDD PMOS_4T_8744924_X3_Y2_1774869528
XSCM_NMOS_72619132_X7_Y1_1774869530_0 IB li_663_2839# VSS SCM_NMOS_72619132_X7_Y1_1774869530
XNMOS_4T_28886488_X2_Y1_1774869527_0 m1_1860_2828# VIN li_663_2839# VSS NMOS_4T_28886488_X2_Y1_1774869527
XNMOS_4T_28886488_X2_Y1_1774869527_1 m1_430_2744# VIP li_663_2839# VSS NMOS_4T_28886488_X2_Y1_1774869527
.ends
