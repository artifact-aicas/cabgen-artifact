* NGSPICE file created from TELESCOPIC_OTA_0.ext - technology: sky130A

.subckt PMOS_S_26075639_X3_Y2_1774869254 a_230_357# a_200_252# w_0_0# VSUBS
X0 a_230_357# a_200_252# w_0_0# w_0_0# sky130_fd_pr__pfet_01v8 ad=0.294 pd=2.38 as=0.5565 ps=4.73 w=2.1 l=0.15
X1 w_0_0# a_200_252# a_230_357# w_0_0# sky130_fd_pr__pfet_01v8 ad=0.294 pd=2.38 as=0.294 ps=2.38 w=2.1 l=0.15
X2 w_0_0# a_200_252# a_230_357# w_0_0# sky130_fd_pr__pfet_01v8 ad=0.5565 pd=4.73 as=0.294 ps=2.38 w=2.1 l=0.15
X3 a_230_357# a_200_252# w_0_0# w_0_0# sky130_fd_pr__pfet_01v8 ad=0.294 pd=2.38 as=0.294 ps=2.38 w=2.1 l=0.15
X4 w_0_0# a_200_252# a_230_357# w_0_0# sky130_fd_pr__pfet_01v8 ad=0.294 pd=2.38 as=0.294 ps=2.38 w=2.1 l=0.15
X5 a_230_357# a_200_252# w_0_0# w_0_0# sky130_fd_pr__pfet_01v8 ad=0.294 pd=2.38 as=0.5565 ps=4.73 w=2.1 l=0.15
X6 w_0_0# a_200_252# a_230_357# w_0_0# sky130_fd_pr__pfet_01v8 ad=0.294 pd=2.38 as=0.294 ps=2.38 w=2.1 l=0.15
X7 a_230_357# a_200_252# w_0_0# w_0_0# sky130_fd_pr__pfet_01v8 ad=0.294 pd=2.38 as=0.294 ps=2.38 w=2.1 l=0.15
X8 w_0_0# a_200_252# a_230_357# w_0_0# sky130_fd_pr__pfet_01v8 ad=0.294 pd=2.38 as=0.294 ps=2.38 w=2.1 l=0.15
X9 w_0_0# a_200_252# a_230_357# w_0_0# sky130_fd_pr__pfet_01v8 ad=0.5565 pd=4.73 as=0.294 ps=2.38 w=2.1 l=0.15
X10 a_230_357# a_200_252# w_0_0# w_0_0# sky130_fd_pr__pfet_01v8 ad=0.294 pd=2.38 as=0.294 ps=2.38 w=2.1 l=0.15
X11 a_230_357# a_200_252# w_0_0# w_0_0# sky130_fd_pr__pfet_01v8 ad=0.294 pd=2.38 as=0.294 ps=2.38 w=2.1 l=0.15
C0 a_200_252# w_0_0# 3.14482f
C1 a_230_357# a_200_252# 0.943272f
C2 a_230_357# w_0_0# 4.81368f
C3 a_230_357# VSUBS 0.310557f
C4 a_200_252# VSUBS 0.53327f
C5 w_0_0# VSUBS 7.55444f
.ends

.subckt SCM_NMOS_72619132_X7_Y1_1774869255 a_200_252# a_402_357# a_147_357#
X0 a_200_252# a_200_252# a_147_357# a_147_357# sky130_fd_pr__nfet_01v8 ad=0.294 pd=2.38 as=0.294 ps=2.38 w=2.1 l=0.15
X1 a_147_357# a_200_252# a_402_357# a_147_357# sky130_fd_pr__nfet_01v8 ad=0.294 pd=2.38 as=0.294 ps=2.38 w=2.1 l=0.15
X2 a_147_357# a_200_252# a_402_357# a_147_357# sky130_fd_pr__nfet_01v8 ad=0.5565 pd=4.73 as=0.294 ps=2.38 w=2.1 l=0.15
X3 a_147_357# a_200_252# a_200_252# a_147_357# sky130_fd_pr__nfet_01v8 ad=0.294 pd=2.38 as=0.294 ps=2.38 w=2.1 l=0.15
X4 a_147_357# a_200_252# a_200_252# a_147_357# sky130_fd_pr__nfet_01v8 ad=0.294 pd=2.38 as=0.294 ps=2.38 w=2.1 l=0.15
X5 a_200_252# a_200_252# a_147_357# a_147_357# sky130_fd_pr__nfet_01v8 ad=0.294 pd=2.38 as=0.5565 ps=4.73 w=2.1 l=0.15
X6 a_147_357# a_200_252# a_200_252# a_147_357# sky130_fd_pr__nfet_01v8 ad=0.294 pd=2.38 as=0.294 ps=2.38 w=2.1 l=0.15
X7 a_402_357# a_200_252# a_147_357# a_147_357# sky130_fd_pr__nfet_01v8 ad=0.294 pd=2.38 as=0.294 ps=2.38 w=2.1 l=0.15
X8 a_147_357# a_200_252# a_200_252# a_147_357# sky130_fd_pr__nfet_01v8 ad=0.294 pd=2.38 as=0.294 ps=2.38 w=2.1 l=0.15
X9 a_200_252# a_200_252# a_147_357# a_147_357# sky130_fd_pr__nfet_01v8 ad=0.294 pd=2.38 as=0.294 ps=2.38 w=2.1 l=0.15
X10 a_402_357# a_200_252# a_147_357# a_147_357# sky130_fd_pr__nfet_01v8 ad=0.294 pd=2.38 as=0.294 ps=2.38 w=2.1 l=0.15
X11 a_402_357# a_200_252# a_147_357# a_147_357# sky130_fd_pr__nfet_01v8 ad=0.294 pd=2.38 as=0.294 ps=2.38 w=2.1 l=0.15
X12 a_147_357# a_200_252# a_402_357# a_147_357# sky130_fd_pr__nfet_01v8 ad=0.294 pd=2.38 as=0.294 ps=2.38 w=2.1 l=0.15
X13 a_402_357# a_200_252# a_147_357# a_147_357# sky130_fd_pr__nfet_01v8 ad=0.294 pd=2.38 as=0.294 ps=2.38 w=2.1 l=0.15
X14 a_147_357# a_200_252# a_402_357# a_147_357# sky130_fd_pr__nfet_01v8 ad=0.294 pd=2.38 as=0.294 ps=2.38 w=2.1 l=0.15
X15 a_147_357# a_200_252# a_200_252# a_147_357# sky130_fd_pr__nfet_01v8 ad=0.294 pd=2.38 as=0.294 ps=2.38 w=2.1 l=0.15
X16 a_402_357# a_200_252# a_147_357# a_147_357# sky130_fd_pr__nfet_01v8 ad=0.294 pd=2.38 as=0.294 ps=2.38 w=2.1 l=0.15
X17 a_147_357# a_200_252# a_402_357# a_147_357# sky130_fd_pr__nfet_01v8 ad=0.294 pd=2.38 as=0.294 ps=2.38 w=2.1 l=0.15
X18 a_200_252# a_200_252# a_147_357# a_147_357# sky130_fd_pr__nfet_01v8 ad=0.294 pd=2.38 as=0.294 ps=2.38 w=2.1 l=0.15
X19 a_200_252# a_200_252# a_147_357# a_147_357# sky130_fd_pr__nfet_01v8 ad=0.294 pd=2.38 as=0.294 ps=2.38 w=2.1 l=0.15
X20 a_147_357# a_200_252# a_200_252# a_147_357# sky130_fd_pr__nfet_01v8 ad=0.294 pd=2.38 as=0.294 ps=2.38 w=2.1 l=0.15
X21 a_402_357# a_200_252# a_147_357# a_147_357# sky130_fd_pr__nfet_01v8 ad=0.294 pd=2.38 as=0.294 ps=2.38 w=2.1 l=0.15
X22 a_147_357# a_200_252# a_402_357# a_147_357# sky130_fd_pr__nfet_01v8 ad=0.294 pd=2.38 as=0.294 ps=2.38 w=2.1 l=0.15
X23 a_402_357# a_200_252# a_147_357# a_147_357# sky130_fd_pr__nfet_01v8 ad=0.294 pd=2.38 as=0.294 ps=2.38 w=2.1 l=0.15
X24 a_147_357# a_200_252# a_402_357# a_147_357# sky130_fd_pr__nfet_01v8 ad=0.294 pd=2.38 as=0.294 ps=2.38 w=2.1 l=0.15
X25 a_200_252# a_200_252# a_147_357# a_147_357# sky130_fd_pr__nfet_01v8 ad=0.294 pd=2.38 as=0.294 ps=2.38 w=2.1 l=0.15
X26 a_200_252# a_200_252# a_147_357# a_147_357# sky130_fd_pr__nfet_01v8 ad=0.294 pd=2.38 as=0.294 ps=2.38 w=2.1 l=0.15
X27 a_147_357# a_200_252# a_200_252# a_147_357# sky130_fd_pr__nfet_01v8 ad=0.294 pd=2.38 as=0.294 ps=2.38 w=2.1 l=0.15
C0 a_402_357# a_200_252# 1.93269f
C1 a_402_357# a_147_357# 5.97736f
C2 a_200_252# a_147_357# 11.444099f
.ends

.subckt NMOS_4T_1818045_X10_Y1_1774869251 a_230_357# a_200_252# a_147_357# a_241_1232#
X0 a_230_357# a_200_252# a_147_357# a_241_1232# sky130_fd_pr__nfet_01v8 ad=0.294 pd=2.38 as=0.294 ps=2.38 w=2.1 l=0.15
X1 a_147_357# a_200_252# a_230_357# a_241_1232# sky130_fd_pr__nfet_01v8 ad=0.294 pd=2.38 as=0.294 ps=2.38 w=2.1 l=0.15
X2 a_147_357# a_200_252# a_230_357# a_241_1232# sky130_fd_pr__nfet_01v8 ad=0.294 pd=2.38 as=0.294 ps=2.38 w=2.1 l=0.15
X3 a_230_357# a_200_252# a_147_357# a_241_1232# sky130_fd_pr__nfet_01v8 ad=0.294 pd=2.38 as=0.5565 ps=4.73 w=2.1 l=0.15
X4 a_147_357# a_200_252# a_230_357# a_241_1232# sky130_fd_pr__nfet_01v8 ad=0.294 pd=2.38 as=0.294 ps=2.38 w=2.1 l=0.15
X5 a_230_357# a_200_252# a_147_357# a_241_1232# sky130_fd_pr__nfet_01v8 ad=0.294 pd=2.38 as=0.294 ps=2.38 w=2.1 l=0.15
X6 a_147_357# a_200_252# a_230_357# a_241_1232# sky130_fd_pr__nfet_01v8 ad=0.294 pd=2.38 as=0.294 ps=2.38 w=2.1 l=0.15
X7 a_230_357# a_200_252# a_147_357# a_241_1232# sky130_fd_pr__nfet_01v8 ad=0.294 pd=2.38 as=0.294 ps=2.38 w=2.1 l=0.15
X8 a_230_357# a_200_252# a_147_357# a_241_1232# sky130_fd_pr__nfet_01v8 ad=0.294 pd=2.38 as=0.294 ps=2.38 w=2.1 l=0.15
X9 a_147_357# a_200_252# a_230_357# a_241_1232# sky130_fd_pr__nfet_01v8 ad=0.294 pd=2.38 as=0.294 ps=2.38 w=2.1 l=0.15
X10 a_230_357# a_200_252# a_147_357# a_241_1232# sky130_fd_pr__nfet_01v8 ad=0.294 pd=2.38 as=0.294 ps=2.38 w=2.1 l=0.15
X11 a_147_357# a_200_252# a_230_357# a_241_1232# sky130_fd_pr__nfet_01v8 ad=0.5565 pd=4.73 as=0.294 ps=2.38 w=2.1 l=0.15
X12 a_230_357# a_200_252# a_147_357# a_241_1232# sky130_fd_pr__nfet_01v8 ad=0.294 pd=2.38 as=0.294 ps=2.38 w=2.1 l=0.15
X13 a_147_357# a_200_252# a_230_357# a_241_1232# sky130_fd_pr__nfet_01v8 ad=0.294 pd=2.38 as=0.294 ps=2.38 w=2.1 l=0.15
X14 a_230_357# a_200_252# a_147_357# a_241_1232# sky130_fd_pr__nfet_01v8 ad=0.294 pd=2.38 as=0.294 ps=2.38 w=2.1 l=0.15
X15 a_147_357# a_200_252# a_230_357# a_241_1232# sky130_fd_pr__nfet_01v8 ad=0.294 pd=2.38 as=0.294 ps=2.38 w=2.1 l=0.15
X16 a_147_357# a_200_252# a_230_357# a_241_1232# sky130_fd_pr__nfet_01v8 ad=0.294 pd=2.38 as=0.294 ps=2.38 w=2.1 l=0.15
X17 a_230_357# a_200_252# a_147_357# a_241_1232# sky130_fd_pr__nfet_01v8 ad=0.294 pd=2.38 as=0.294 ps=2.38 w=2.1 l=0.15
X18 a_230_357# a_200_252# a_147_357# a_241_1232# sky130_fd_pr__nfet_01v8 ad=0.294 pd=2.38 as=0.294 ps=2.38 w=2.1 l=0.15
X19 a_147_357# a_200_252# a_230_357# a_241_1232# sky130_fd_pr__nfet_01v8 ad=0.294 pd=2.38 as=0.294 ps=2.38 w=2.1 l=0.15
C0 a_147_357# a_200_252# 0.792671f
C1 a_230_357# a_147_357# 7.00558f
C2 a_230_357# a_200_252# 0.788815f
C3 a_230_357# a_241_1232# 0.702196f
C4 a_147_357# a_241_1232# 0.814383f
C5 a_200_252# a_241_1232# 3.34033f
.ends

.subckt NMOS_4T_97331930_X4_Y1_1774869252 a_230_357# a_200_252# a_147_357# a_241_1232#
X0 a_230_357# a_200_252# a_147_357# a_241_1232# sky130_fd_pr__nfet_01v8 ad=0.294 pd=2.38 as=0.294 ps=2.38 w=2.1 l=0.15
X1 a_230_357# a_200_252# a_147_357# a_241_1232# sky130_fd_pr__nfet_01v8 ad=0.294 pd=2.38 as=0.5565 ps=4.73 w=2.1 l=0.15
X2 a_147_357# a_200_252# a_230_357# a_241_1232# sky130_fd_pr__nfet_01v8 ad=0.294 pd=2.38 as=0.294 ps=2.38 w=2.1 l=0.15
X3 a_147_357# a_200_252# a_230_357# a_241_1232# sky130_fd_pr__nfet_01v8 ad=0.294 pd=2.38 as=0.294 ps=2.38 w=2.1 l=0.15
X4 a_230_357# a_200_252# a_147_357# a_241_1232# sky130_fd_pr__nfet_01v8 ad=0.294 pd=2.38 as=0.294 ps=2.38 w=2.1 l=0.15
X5 a_230_357# a_200_252# a_147_357# a_241_1232# sky130_fd_pr__nfet_01v8 ad=0.294 pd=2.38 as=0.294 ps=2.38 w=2.1 l=0.15
X6 a_147_357# a_200_252# a_230_357# a_241_1232# sky130_fd_pr__nfet_01v8 ad=0.294 pd=2.38 as=0.294 ps=2.38 w=2.1 l=0.15
X7 a_147_357# a_200_252# a_230_357# a_241_1232# sky130_fd_pr__nfet_01v8 ad=0.5565 pd=4.73 as=0.294 ps=2.38 w=2.1 l=0.15
C0 a_147_357# a_200_252# 0.309762f
C1 a_230_357# a_147_357# 2.76354f
C2 a_230_357# a_200_252# 0.315281f
C3 a_230_357# a_241_1232# 0.279287f
C4 a_147_357# a_241_1232# 0.557684f
C5 a_200_252# a_241_1232# 1.43268f
.ends

.subckt PMOS_4T_28463424_X4_Y1_1774869253 a_230_357# a_200_252# a_147_357# w_0_0#
+ VSUBS
X0 a_230_357# a_200_252# a_147_357# w_0_0# sky130_fd_pr__pfet_01v8 ad=0.294 pd=2.38 as=0.5565 ps=4.73 w=2.1 l=0.15
X1 a_147_357# a_200_252# a_230_357# w_0_0# sky130_fd_pr__pfet_01v8 ad=0.294 pd=2.38 as=0.294 ps=2.38 w=2.1 l=0.15
X2 a_147_357# a_200_252# a_230_357# w_0_0# sky130_fd_pr__pfet_01v8 ad=0.294 pd=2.38 as=0.294 ps=2.38 w=2.1 l=0.15
X3 a_230_357# a_200_252# a_147_357# w_0_0# sky130_fd_pr__pfet_01v8 ad=0.294 pd=2.38 as=0.294 ps=2.38 w=2.1 l=0.15
X4 a_230_357# a_200_252# a_147_357# w_0_0# sky130_fd_pr__pfet_01v8 ad=0.294 pd=2.38 as=0.294 ps=2.38 w=2.1 l=0.15
X5 a_147_357# a_200_252# a_230_357# w_0_0# sky130_fd_pr__pfet_01v8 ad=0.294 pd=2.38 as=0.294 ps=2.38 w=2.1 l=0.15
X6 a_147_357# a_200_252# a_230_357# w_0_0# sky130_fd_pr__pfet_01v8 ad=0.5565 pd=4.73 as=0.294 ps=2.38 w=2.1 l=0.15
X7 a_230_357# a_200_252# a_147_357# w_0_0# sky130_fd_pr__pfet_01v8 ad=0.294 pd=2.38 as=0.294 ps=2.38 w=2.1 l=0.15
C0 a_147_357# a_230_357# 2.76354f
C1 a_200_252# w_0_0# 1.16388f
C2 a_200_252# a_230_357# 0.315281f
C3 w_0_0# a_230_357# 0.117804f
C4 a_147_357# a_200_252# 0.309762f
C5 a_147_357# w_0_0# 0.274639f
C6 a_230_357# VSUBS 0.161483f
C7 a_147_357# VSUBS 0.283045f
C8 a_200_252# VSUBS 0.268825f
C9 w_0_0# VSUBS 4.84666f
.ends

.subckt TELESCOPIC_OTA_0 IB VCN VOUT VIP VIN VCP VSS VDD
XPMOS_S_26075639_X3_Y2_1774869254_0 m1_656_1316# m1_570_1484# VDD VSS PMOS_S_26075639_X3_Y2_1774869254
XPMOS_S_26075639_X3_Y2_1774869254_1 m1_2924_1316# m1_570_1484# VDD VSS PMOS_S_26075639_X3_Y2_1774869254
XSCM_NMOS_72619132_X7_Y1_1774869255_0 IB m1_1860_3164# VSS SCM_NMOS_72619132_X7_Y1_1774869255
XNMOS_4T_1818045_X10_Y1_1774869251_0 m1_1258_2828# VIN m1_1860_3164# VSS NMOS_4T_1818045_X10_Y1_1774869251
XNMOS_4T_1818045_X10_Y1_1774869251_1 m1_2806_2828# VIP m1_1860_3164# VSS NMOS_4T_1818045_X10_Y1_1774869251
XNMOS_4T_97331930_X4_Y1_1774869252_0 VOUT VCN m1_1258_2828# VSS NMOS_4T_97331930_X4_Y1_1774869252
XPMOS_4T_28463424_X4_Y1_1774869253_0 VOUT VCP m1_656_1316# VDD VSS PMOS_4T_28463424_X4_Y1_1774869253
XNMOS_4T_97331930_X4_Y1_1774869252_1 m1_570_1484# VCN m1_2806_2828# VSS NMOS_4T_97331930_X4_Y1_1774869252
XPMOS_4T_28463424_X4_Y1_1774869253_1 m1_570_1484# VCP m1_2924_1316# VDD VSS PMOS_4T_28463424_X4_Y1_1774869253
R0 VDD.n9 VDD.t5 943.371
R1 VDD.n14 VDD.t11 943.371
R2 VDD.n12 VDD.t15 943.371
R3 VDD.n9 VDD.t3 906.915
R4 VDD.t14 VDD.n0 402.825
R5 VDD.n2 VDD.n1 379.685
R6 VDD.n7 VDD.n6 379.493
R7 VDD.n3 VDD.n1 379.3
R8 VDD.n9 VDD.n8 202.751
R9 VDD.n14 VDD.n13 202.751
R10 VDD.n12 VDD.n11 202.751
R11 VDD.t2 VDD.t12 30.3948
R12 VDD.t0 VDD.t6 30.3948
R13 VDD.t4 VDD.n5 30.3948
R14 VDD.n5 VDD.n4 30.3948
R15 VDD.n2 VDD.t14 15.1977
R16 VDD.t12 VDD.n2 15.1977
R17 VDD.n3 VDD.t2 15.1977
R18 VDD.t6 VDD.n3 15.1977
R19 VDD.n6 VDD.t0 15.1977
R20 VDD.n6 VDD.t4 15.1977
R21 VDD.n8 VDD.t9 13.1338
R22 VDD.n8 VDD.t8 13.1338
R23 VDD.n13 VDD.t7 13.1338
R24 VDD.n13 VDD.t1 13.1338
R25 VDD.n11 VDD.t13 13.1338
R26 VDD.n11 VDD.t10 13.1338
R27 VDD.n10 VDD.n7 7.1255
R28 VDD.n0 VDD 4.6125
R29 VDD.n16 VDD.n15 4.5355
R30 VDD.n15 VDD.n14 4.5005
R31 VDD.n10 VDD.n9 4.5005
R32 VDD VDD.n16 4.08903
R33 VDD.n15 VDD.n10 2.6255
R34 VDD.n14 VDD.n12 0.384429
R35 VDD.n16 VDD.n0 0.264942
R36 VDD.n7 VDD.n1 0.192464
R37 m1_656_1316.n5 m1_656_1316.n3 224.639
R38 m1_656_1316.n2 m1_656_1316.n0 224.639
R39 m1_656_1316.n7 m1_656_1316.n6 224.445
R40 m1_656_1316.n2 m1_656_1316.n1 224.256
R41 m1_656_1316.n5 m1_656_1316.n4 224.256
R42 m1_656_1316.n0 m1_656_1316.t0 13.1338
R43 m1_656_1316.n0 m1_656_1316.t7 13.1338
R44 m1_656_1316.n1 m1_656_1316.t6 13.1338
R45 m1_656_1316.n1 m1_656_1316.t3 13.1338
R46 m1_656_1316.n3 m1_656_1316.t4 13.1338
R47 m1_656_1316.n3 m1_656_1316.t2 13.1338
R48 m1_656_1316.n4 m1_656_1316.t1 13.1338
R49 m1_656_1316.n4 m1_656_1316.t5 13.1338
R50 m1_656_1316.t9 m1_656_1316.n7 13.1338
R51 m1_656_1316.n7 m1_656_1316.t8 13.1338
R52 m1_656_1316.n6 m1_656_1316.n5 11.8175
R53 m1_656_1316.n6 m1_656_1316.n2 0.192464
R54 IB.n14 IB.t20 568.582
R55 IB.n14 IB.t18 568.582
R56 IB.n15 IB.t34 568.582
R57 IB.n15 IB.t39 568.582
R58 IB.n17 IB.t26 568.582
R59 IB.n17 IB.t16 568.582
R60 IB.n19 IB.t36 568.582
R61 IB.n19 IB.t41 568.582
R62 IB.n21 IB.t4 568.582
R63 IB.n21 IB.t24 568.582
R64 IB.n23 IB.t31 568.582
R65 IB.n23 IB.t37 568.582
R66 IB.n13 IB.t2 568.582
R67 IB.n13 IB.t22 568.582
R68 IB.n11 IB.t32 568.582
R69 IB.n11 IB.t33 568.582
R70 IB.n9 IB.t10 568.582
R71 IB.n9 IB.t0 568.582
R72 IB.n7 IB.t30 568.582
R73 IB.n7 IB.t35 568.582
R74 IB.n5 IB.t8 568.582
R75 IB.n5 IB.t6 568.582
R76 IB.n3 IB.t38 568.582
R77 IB.n3 IB.t28 568.582
R78 IB.n1 IB.t14 568.582
R79 IB.n1 IB.t12 568.582
R80 IB.n0 IB.t40 568.582
R81 IB.n0 IB.t29 568.582
R82 IB.n16 IB.n14 161.685
R83 IB.n2 IB.n0 161.685
R84 IB.n16 IB.n15 161.3
R85 IB.n18 IB.n17 161.3
R86 IB.n20 IB.n19 161.3
R87 IB.n22 IB.n21 161.3
R88 IB.n24 IB.n23 161.3
R89 IB.n25 IB.n13 161.3
R90 IB.n12 IB.n11 161.3
R91 IB.n10 IB.n9 161.3
R92 IB.n8 IB.n7 161.3
R93 IB.n6 IB.n5 161.3
R94 IB.n4 IB.n3 161.3
R95 IB.n2 IB.n1 161.3
R96 IB.n34 IB.n32 142.79
R97 IB.n28 IB.n26 142.79
R98 IB.n34 IB.n33 142.023
R99 IB.n36 IB.n35 142.023
R100 IB.n37 IB.n31 142.023
R101 IB.n30 IB.n29 142.023
R102 IB.n28 IB.n27 142.023
R103 IB.n32 IB.t19 8.0005
R104 IB.n32 IB.t21 8.0005
R105 IB.n33 IB.t17 8.0005
R106 IB.n33 IB.t27 8.0005
R107 IB.n35 IB.t25 8.0005
R108 IB.n35 IB.t5 8.0005
R109 IB.n31 IB.t23 8.0005
R110 IB.n31 IB.t3 8.0005
R111 IB.n29 IB.t1 8.0005
R112 IB.n29 IB.t11 8.0005
R113 IB.n27 IB.t7 8.0005
R114 IB.n27 IB.t9 8.0005
R115 IB.n26 IB.t13 8.0005
R116 IB.n26 IB.t15 8.0005
R117 IB IB.n25 5.438
R118 IB IB.n37 5.438
R119 IB.n30 IB.n28 0.768357
R120 IB.n37 IB.n30 0.768357
R121 IB.n37 IB.n36 0.768357
R122 IB.n36 IB.n34 0.768357
R123 IB.n4 IB.n2 0.384429
R124 IB.n6 IB.n4 0.384429
R125 IB.n8 IB.n6 0.384429
R126 IB.n10 IB.n8 0.384429
R127 IB.n12 IB.n10 0.384429
R128 IB.n25 IB.n12 0.384429
R129 IB.n25 IB.n24 0.384429
R130 IB.n24 IB.n22 0.384429
R131 IB.n22 IB.n20 0.384429
R132 IB.n20 IB.n18 0.384429
R133 IB.n18 IB.n16 0.384429
R134 VSS.n22 VSS.n21 185044
R135 VSS.n32 VSS.n6 1179.3
R136 VSS.n31 VSS.n7 1179.3
R137 VSS.n10 VSS.n8 1179.3
R138 VSS.n27 VSS.n11 1179.3
R139 VSS.n26 VSS.n12 1179.3
R140 VSS.n25 VSS.n13 1179.3
R141 VSS.n15 VSS.n14 1179.3
R142 VSS.n22 VSS.n17 1179.3
R143 VSS.n3 VSS.n1 1179.3
R144 VSS.n37 VSS.n36 1179.3
R145 VSS.n35 VSS.n2 1179.3
R146 VSS.n34 VSS.n33 1179.3
R147 VSS.n32 VSS.n4 1179.3
R148 VSS.n31 VSS.n30 1179.3
R149 VSS.n29 VSS.n8 1179.3
R150 VSS.n28 VSS.n27 1179.3
R151 VSS.n26 VSS.n9 1179.3
R152 VSS.n25 VSS.n24 1179.3
R153 VSS.n20 VSS.n19 1179.3
R154 VSS.n39 VSS.n38 661.676
R155 VSS.n18 VSS.n3 533.053
R156 VSS.n24 VSS.n23 533.053
R157 VSS.n6 VSS.n5 533.053
R158 VSS.n21 VSS.n18 530.135
R159 VSS.n19 VSS.n1 252.773
R160 VSS.n37 VSS.n2 252.773
R161 VSS.n33 VSS.n32 252.773
R162 VSS.n32 VSS.n31 252.773
R163 VSS.n31 VSS.n8 252.773
R164 VSS.n27 VSS.n8 252.773
R165 VSS.n27 VSS.n26 252.773
R166 VSS.n26 VSS.n25 252.773
R167 VSS.n25 VSS.n14 252.773
R168 VSS.n38 VSS.n1 126.386
R169 VSS.n38 VSS.n37 126.386
R170 VSS.n5 VSS.n2 114.174
R171 VSS.n23 VSS.n22 114.174
R172 VSS.n33 VSS.n5 114.136
R173 VSS.n19 VSS.n18 114.136
R174 VSS.n23 VSS.n14 114.136
R175 VSS.n21 VSS.n20 19.0003
R176 VSS.n17 VSS.n16 10.3267
R177 VSS.n20 VSS.n0 9.973
R178 VSS.n16 VSS.n4 9.223
R179 VSS VSS.n39 5.35255
R180 VSS VSS.n0 3.95097
R181 VSS.n39 VSS 1.74773
R182 VSS.n36 VSS.n3 0.384429
R183 VSS.n36 VSS.n35 0.384429
R184 VSS.n35 VSS.n34 0.384429
R185 VSS.n34 VSS.n4 0.384429
R186 VSS.n30 VSS.n4 0.384429
R187 VSS.n30 VSS.n29 0.384429
R188 VSS.n29 VSS.n28 0.384429
R189 VSS.n28 VSS.n9 0.384429
R190 VSS.n24 VSS.n9 0.384429
R191 VSS.n7 VSS.n6 0.384429
R192 VSS.n10 VSS.n7 0.384429
R193 VSS.n11 VSS.n10 0.384429
R194 VSS.n12 VSS.n11 0.384429
R195 VSS.n13 VSS.n12 0.384429
R196 VSS.n15 VSS.n13 0.384429
R197 VSS.n17 VSS.n15 0.384429
R198 VSS.n16 VSS.n0 0.253125
R199 VIN.n9 VIN.t3 568.582
R200 VIN.n9 VIN.t4 568.582
R201 VIN.n10 VIN.t10 568.582
R202 VIN.n10 VIN.t15 568.582
R203 VIN.n12 VIN.t0 568.582
R204 VIN.n12 VIN.t6 568.582
R205 VIN.n14 VIN.t12 568.582
R206 VIN.n14 VIN.t16 568.582
R207 VIN.n16 VIN.t17 568.582
R208 VIN.n16 VIN.t1 568.582
R209 VIN.n7 VIN.t7 568.582
R210 VIN.n7 VIN.t13 568.582
R211 VIN.n5 VIN.t18 568.582
R212 VIN.n5 VIN.t2 568.582
R213 VIN.n3 VIN.t8 568.582
R214 VIN.n3 VIN.t9 568.582
R215 VIN.n1 VIN.t14 568.582
R216 VIN.n1 VIN.t19 568.582
R217 VIN.n0 VIN.t5 568.582
R218 VIN.n0 VIN.t11 568.582
R219 VIN.n11 VIN.n9 161.685
R220 VIN.n2 VIN.n0 161.685
R221 VIN.n11 VIN.n10 161.3
R222 VIN.n13 VIN.n12 161.3
R223 VIN.n15 VIN.n14 161.3
R224 VIN.n17 VIN.n16 161.3
R225 VIN.n8 VIN.n7 161.3
R226 VIN.n6 VIN.n5 161.3
R227 VIN.n4 VIN.n3 161.3
R228 VIN.n2 VIN.n1 161.3
R229 VIN.n4 VIN.n2 0.384429
R230 VIN.n6 VIN.n4 0.384429
R231 VIN.n8 VIN.n6 0.384429
R232 VIN.n17 VIN.n15 0.384429
R233 VIN.n15 VIN.n13 0.384429
R234 VIN.n13 VIN.n11 0.384429
R235 VIN VIN.n8 0.192464
R236 VIN VIN.n17 0.192464
R237 VIP.n9 VIP.t11 568.582
R238 VIP.n9 VIP.t5 568.582
R239 VIP.n10 VIP.t19 568.582
R240 VIP.n10 VIP.t14 568.582
R241 VIP.n12 VIP.t9 568.582
R242 VIP.n12 VIP.t8 568.582
R243 VIP.n14 VIP.t2 568.582
R244 VIP.n14 VIP.t18 568.582
R245 VIP.n16 VIP.t13 568.582
R246 VIP.n16 VIP.t7 568.582
R247 VIP.n7 VIP.t1 568.582
R248 VIP.n7 VIP.t17 568.582
R249 VIP.n5 VIP.t16 568.582
R250 VIP.n5 VIP.t12 568.582
R251 VIP.n3 VIP.t6 568.582
R252 VIP.n3 VIP.t0 568.582
R253 VIP.n1 VIP.t15 568.582
R254 VIP.n1 VIP.t10 568.582
R255 VIP.n0 VIP.t4 568.582
R256 VIP.n0 VIP.t3 568.582
R257 VIP.n11 VIP.n9 161.685
R258 VIP.n2 VIP.n0 161.685
R259 VIP.n11 VIP.n10 161.3
R260 VIP.n13 VIP.n12 161.3
R261 VIP.n15 VIP.n14 161.3
R262 VIP.n17 VIP.n16 161.3
R263 VIP.n8 VIP.n7 161.3
R264 VIP.n6 VIP.n5 161.3
R265 VIP.n4 VIP.n3 161.3
R266 VIP.n2 VIP.n1 161.3
R267 VIP.n4 VIP.n2 0.384429
R268 VIP.n6 VIP.n4 0.384429
R269 VIP.n8 VIP.n6 0.384429
R270 VIP.n17 VIP.n15 0.384429
R271 VIP.n15 VIP.n13 0.384429
R272 VIP.n13 VIP.n11 0.384429
R273 VIP VIP.n8 0.192464
R274 VIP VIP.n17 0.192464
R275 VCN.n11 VCN.t5 568.582
R276 VCN.n11 VCN.t7 568.582
R277 VCN.n12 VCN.t0 568.582
R278 VCN.n12 VCN.t3 568.582
R279 VCN.n9 VCN.t4 568.582
R280 VCN.n9 VCN.t6 568.582
R281 VCN.n7 VCN.t1 568.582
R282 VCN.n7 VCN.t2 568.582
R283 VCN.n5 VCN.t10 568.582
R284 VCN.n5 VCN.t9 568.582
R285 VCN.n3 VCN.t14 568.582
R286 VCN.n3 VCN.t12 568.582
R287 VCN.n1 VCN.t11 568.582
R288 VCN.n1 VCN.t8 568.582
R289 VCN.n0 VCN.t15 568.582
R290 VCN.n0 VCN.t13 568.582
R291 VCN.n13 VCN.n11 161.685
R292 VCN.n2 VCN.n0 161.685
R293 VCN.n13 VCN.n12 161.3
R294 VCN.n10 VCN.n9 161.3
R295 VCN.n8 VCN.n7 161.3
R296 VCN.n6 VCN.n5 161.3
R297 VCN.n4 VCN.n3 161.3
R298 VCN.n2 VCN.n1 161.3
R299 VCN.n8 VCN.n6 1.15229
R300 VCN.n4 VCN.n2 0.384429
R301 VCN.n6 VCN.n4 0.384429
R302 VCN.n10 VCN.n8 0.384429
R303 VCN VCN.n10 0.192464
R304 VCN VCN.n13 0.192464
R305 VCP.n11 VCP.t1 568.582
R306 VCP.n11 VCP.t0 568.582
R307 VCP.n12 VCP.t5 568.582
R308 VCP.n12 VCP.t3 568.582
R309 VCP.n9 VCP.t2 568.582
R310 VCP.n9 VCP.t7 568.582
R311 VCP.n7 VCP.t6 568.582
R312 VCP.n7 VCP.t4 568.582
R313 VCP.n5 VCP.t12 568.582
R314 VCP.n5 VCP.t14 568.582
R315 VCP.n3 VCP.t15 568.582
R316 VCP.n3 VCP.t10 568.582
R317 VCP.n1 VCP.t11 568.582
R318 VCP.n1 VCP.t13 568.582
R319 VCP.n0 VCP.t8 568.582
R320 VCP.n0 VCP.t9 568.582
R321 VCP.n13 VCP.n11 161.685
R322 VCP.n2 VCP.n0 161.685
R323 VCP.n13 VCP.n12 161.3
R324 VCP.n10 VCP.n9 161.3
R325 VCP.n8 VCP.n7 161.3
R326 VCP.n6 VCP.n5 161.3
R327 VCP.n4 VCP.n3 161.3
R328 VCP.n2 VCP.n1 161.3
R329 VCP.n8 VCP.n6 1.15229
R330 VCP.n4 VCP.n2 0.384429
R331 VCP.n6 VCP.n4 0.384429
R332 VCP.n10 VCP.n8 0.384429
R333 VCP VCP.n10 0.192464
R334 VCP VCP.n13 0.192464
C0 m1_2924_1316# VOUT 6.19e-19
C1 m1_1258_2828# m1_570_1484# 0.033375f
C2 m1_2806_2828# m1_1860_3164# 0.074764f
C3 VCP m1_570_1484# 0.034305f
C4 VCN m1_2806_2828# 0.013525f
C5 m1_2806_2828# VDD 0.358425f
C6 m1_2924_1316# m1_1860_3164# 4.94e-20
C7 m1_1258_2828# VIN 0.001312f
C8 VIP m1_570_1484# 0.008521f
C9 VCN m1_2924_1316# 0.001636f
C10 IB m1_1860_3164# 0.087737f
C11 VIN m1_570_1484# 0.005632f
C12 m1_2924_1316# VDD 0.32061f
C13 VOUT m1_1258_2828# 0.403339f
C14 VCP VOUT 7.6e-20
C15 IB VDD 0.068331f
C16 VOUT m1_570_1484# 0.460424f
C17 VIN VIP 0.027605f
C18 m1_1258_2828# m1_1860_3164# 0.105678f
C19 VCN m1_1258_2828# 0.013525f
C20 m1_570_1484# m1_1860_3164# 0.005336f
C21 VCN VCP 0.014618f
C22 VOUT VIN 0.001576f
C23 VDD m1_1258_2828# 0.483157f
C24 VCN m1_570_1484# 0.058161f
C25 VCP VDD 0.30418f
C26 VDD m1_570_1484# 1.0301f
C27 VIP m1_1860_3164# 0.027271f
C28 VCN VIP 0.007619f
C29 VIN m1_1860_3164# 0.07614f
C30 VCN VIN 0.007619f
C31 VDD VIP 0.203307f
C32 VDD VIN 0.240162f
C33 VOUT m1_1860_3164# 0.006194f
C34 VCN VOUT 0.139877f
C35 m1_2806_2828# m1_2924_1316# 0.007781f
C36 VOUT VDD 0.116924f
C37 VCN m1_1860_3164# 0.012666f
C38 VDD m1_1860_3164# 0.714709f
C39 VCN VDD 0.143566f
C40 m1_2806_2828# m1_1258_2828# 0.07511f
C41 m1_2806_2828# m1_570_1484# 0.556966f
C42 VCP m1_2924_1316# 0.026019f
C43 m1_2806_2828# VIP 0.001312f
C44 m1_2924_1316# m1_570_1484# 0.607925f
C45 IB m1_1258_2828# 0.002996f
C46 m1_2806_2828# VOUT 0.014112f
C47 IB VIP 0.004721f
C48 IB VIN 0.022531f
C49 VCP VSS 0.531368f
C50 VCN VSS 3.005943f
C51 m1_570_1484# VSS 2.214659f
C52 VCP.t8 VSS 0.051777f
C53 VCP.t9 VSS 0.051777f
C54 VCP.n0 VSS 0.095794f
C55 VCP.t11 VSS 0.051777f
C56 VCP.t13 VSS 0.051777f
C57 VCP.n1 VSS 0.095561f
C58 VCP.n2 VSS 0.213634f
C59 VCP.t15 VSS 0.051777f
C60 VCP.t10 VSS 0.051777f
C61 VCP.n3 VSS 0.095561f
C62 VCP.n4 VSS 0.115733f
C63 VCP.t12 VSS 0.051777f
C64 VCP.t14 VSS 0.051777f
C65 VCP.n5 VSS 0.095561f
C66 VCP.n6 VSS 0.173945f
C67 VCP.t6 VSS 0.051777f
C68 VCP.t4 VSS 0.051777f
C69 VCP.n7 VSS 0.095561f
C70 VCP.n8 VSS 0.173945f
C71 VCP.t2 VSS 0.051777f
C72 VCP.t7 VSS 0.051777f
C73 VCP.n9 VSS 0.095561f
C74 VCP.n10 VSS 0.10118f
C75 VCP.t1 VSS 0.051777f
C76 VCP.t0 VSS 0.051777f
C77 VCP.n11 VSS 0.095794f
C78 VCP.t5 VSS 0.051777f
C79 VCP.t3 VSS 0.051777f
C80 VCP.n12 VSS 0.095561f
C81 VCP.n13 VSS 0.199081f
C82 IB.t29 VSS 0.013127f
C83 IB.t40 VSS 0.013127f
C84 IB.n0 VSS 0.024287f
C85 IB.t12 VSS 0.013127f
C86 IB.t14 VSS 0.013127f
C87 IB.n1 VSS 0.024228f
C88 IB.n2 VSS 0.054163f
C89 IB.t28 VSS 0.013127f
C90 IB.t38 VSS 0.013127f
C91 IB.n3 VSS 0.024228f
C92 IB.n4 VSS 0.029342f
C93 IB.t6 VSS 0.013127f
C94 IB.t8 VSS 0.013127f
C95 IB.n5 VSS 0.024228f
C96 IB.n6 VSS 0.029342f
C97 IB.t35 VSS 0.013127f
C98 IB.t30 VSS 0.013127f
C99 IB.n7 VSS 0.024228f
C100 IB.n8 VSS 0.029342f
C101 IB.t0 VSS 0.013127f
C102 IB.t10 VSS 0.013127f
C103 IB.n9 VSS 0.024228f
C104 IB.n10 VSS 0.029342f
C105 IB.t33 VSS 0.013127f
C106 IB.t32 VSS 0.013127f
C107 IB.n11 VSS 0.024228f
C108 IB.n12 VSS 0.029342f
C109 IB.t22 VSS 0.013127f
C110 IB.t2 VSS 0.013127f
C111 IB.n13 VSS 0.024228f
C112 IB.t18 VSS 0.013127f
C113 IB.t20 VSS 0.013127f
C114 IB.n14 VSS 0.024287f
C115 IB.t39 VSS 0.013127f
C116 IB.t34 VSS 0.013127f
C117 IB.n15 VSS 0.024228f
C118 IB.n16 VSS 0.054163f
C119 IB.t16 VSS 0.013127f
C120 IB.t26 VSS 0.013127f
C121 IB.n17 VSS 0.024228f
C122 IB.n18 VSS 0.029342f
C123 IB.t41 VSS 0.013127f
C124 IB.t36 VSS 0.013127f
C125 IB.n19 VSS 0.024228f
C126 IB.n20 VSS 0.029342f
C127 IB.t24 VSS 0.013127f
C128 IB.t4 VSS 0.013127f
C129 IB.n21 VSS 0.024228f
C130 IB.n22 VSS 0.029342f
C131 IB.t37 VSS 0.013127f
C132 IB.t31 VSS 0.013127f
C133 IB.n23 VSS 0.024228f
C134 IB.n24 VSS 0.029342f
C135 IB.n25 VSS 0.032922f
C136 IB.t13 VSS 0.00901f
C137 IB.t15 VSS 0.00901f
C138 IB.n26 VSS 0.048794f
C139 IB.t7 VSS 0.00901f
C140 IB.t9 VSS 0.00901f
C141 IB.n27 VSS 0.048572f
C142 IB.n28 VSS 0.094041f
C143 IB.t1 VSS 0.00901f
C144 IB.t11 VSS 0.00901f
C145 IB.n29 VSS 0.048572f
C146 IB.n30 VSS 0.053052f
C147 IB.t23 VSS 0.00901f
C148 IB.t3 VSS 0.00901f
C149 IB.n31 VSS 0.048572f
C150 IB.t19 VSS 0.00901f
C151 IB.t21 VSS 0.00901f
C152 IB.n32 VSS 0.048794f
C153 IB.t17 VSS 0.00901f
C154 IB.t27 VSS 0.00901f
C155 IB.n33 VSS 0.048572f
C156 IB.n34 VSS 0.094041f
C157 IB.t25 VSS 0.00901f
C158 IB.t5 VSS 0.00901f
C159 IB.n35 VSS 0.048572f
C160 IB.n36 VSS 0.053052f
C161 IB.n37 VSS 0.056632f
C162 m1_656_1316.t8 VSS 0.058715f
C163 m1_656_1316.t0 VSS 0.058715f
C164 m1_656_1316.t7 VSS 0.058715f
C165 m1_656_1316.n0 VSS 0.246433f
C166 m1_656_1316.t6 VSS 0.058715f
C167 m1_656_1316.t3 VSS 0.058715f
C168 m1_656_1316.n1 VSS 0.245936f
C169 m1_656_1316.n2 VSS 0.586706f
C170 m1_656_1316.t4 VSS 0.058715f
C171 m1_656_1316.t2 VSS 0.058715f
C172 m1_656_1316.n3 VSS 0.246433f
C173 m1_656_1316.t1 VSS 0.058715f
C174 m1_656_1316.t5 VSS 0.058715f
C175 m1_656_1316.n4 VSS 0.245936f
C176 m1_656_1316.n5 VSS 3.60657f
C177 m1_656_1316.n6 VSS 2.28868f
C178 m1_656_1316.n7 VSS 0.246164f
C179 m1_656_1316.t9 VSS 0.058715f
C180 VDD.n0 VSS 8.33028f
C181 VDD.n1 VSS 0.051617f
C182 VDD.t14 VSS 2.14302f
C183 VDD.n2 VSS 0.220488f
C184 VDD.t12 VSS 0.341489f
C185 VDD.t2 VSS 0.341489f
C186 VDD.n3 VSS 0.220463f
C187 VDD.t6 VSS 0.341489f
C188 VDD.t0 VSS 0.341489f
C189 VDD.n4 VSS 0.455318f
C190 VDD.n5 VSS 0.455318f
C191 VDD.t4 VSS 0.341489f
C192 VDD.n6 VSS 0.220473f
C193 VDD.n7 VSS 0.055252f
C194 VDD.t3 VSS 0.010381f
C195 VDD.t9 VSS 0.011582f
C196 VDD.t8 VSS 0.011582f
C197 VDD.n8 VSS 0.044441f
C198 VDD.t5 VSS 0.009413f
C199 VDD.n9 VSS 0.435468f
C200 VDD.n10 VSS 0.172904f
C201 VDD.t15 VSS 0.009413f
C202 VDD.t13 VSS 0.011582f
C203 VDD.t10 VSS 0.011582f
C204 VDD.n11 VSS 0.044441f
C205 VDD.n12 VSS 0.184415f
C206 VDD.t7 VSS 0.011582f
C207 VDD.t1 VSS 0.011582f
C208 VDD.n13 VSS 0.044441f
C209 VDD.t11 VSS 0.009413f
C210 VDD.n14 VSS 0.184415f
C211 VDD.n15 VSS 0.116621f
C212 VDD.n16 VSS 0.486617f
C213 m1_2924_1316# VSS 0.408033f
C214 m1_2806_2828# VSS 0.844709f
C215 VOUT VSS 6.716435f
C216 VDD VSS 33.881096f
C217 m1_1258_2828# VSS 0.794345f
C218 VIP VSS 3.37026f
C219 m1_1860_3164# VSS 8.096703f
C220 VIN VSS 3.309138f
C221 IB VSS 12.356452f
.ends
