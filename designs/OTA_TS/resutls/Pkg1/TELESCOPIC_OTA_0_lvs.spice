* NGSPICE file created from TELESCOPIC_OTA_0.ext - technology: sky130A

.subckt PMOS_S_26075639_X3_Y2_1774869254 a_230_357# a_200_252# w_0_0#
X0 a_230_357# a_200_252# w_0_0# w_0_0# sky130_fd_pr__pfet_01v8 ad=0.294 pd=2.38 as=0.5565 ps=4.73 w=2.1 l=0.15 M=12
.ends

.subckt SCM_NMOS_72619132_X7_Y1_1774869255 a_200_252# a_402_357# a_147_357#
X0 a_200_252# a_200_252# a_147_357# a_147_357# sky130_fd_pr__nfet_01v8 ad=0.294 pd=2.38 as=0.294 ps=2.38 w=2.1 l=0.15 M=14
X1 a_147_357# a_200_252# a_402_357# a_147_357# sky130_fd_pr__nfet_01v8 ad=0.294 pd=2.38 as=0.294 ps=2.38 w=2.1 l=0.15 M=14
.ends

.subckt NMOS_4T_1818045_X10_Y1_1774869251 a_230_357# a_200_252# a_147_357# a_241_1232#
X0 a_230_357# a_200_252# a_147_357# a_241_1232# sky130_fd_pr__nfet_01v8 ad=0.294 pd=2.38 as=0.294 ps=2.38 w=2.1 l=0.15 M=20
.ends

.subckt NMOS_4T_97331930_X4_Y1_1774869252 a_230_357# a_200_252# a_147_357# a_241_1232#
X0 a_230_357# a_200_252# a_147_357# a_241_1232# sky130_fd_pr__nfet_01v8 ad=0.294 pd=2.38 as=0.294 ps=2.38 w=2.1 l=0.15 M=8
.ends

.subckt PMOS_4T_28463424_X4_Y1_1774869253 a_230_357# a_200_252# a_147_357# w_0_0#
X0 a_230_357# a_200_252# a_147_357# w_0_0# sky130_fd_pr__pfet_01v8 ad=0.294 pd=2.38 as=0.5565 ps=4.73 w=2.1 l=0.15 M=8
.ends

.subckt TELESCOPIC_OTA_0 IB VCN VOUT VIP VIN VCP VSS VDD
XPMOS_S_26075639_X3_Y2_1774869254_0 m1_656_1316# m1_570_1484# VDD PMOS_S_26075639_X3_Y2_1774869254
XPMOS_S_26075639_X3_Y2_1774869254_1 m1_2924_1316# m1_570_1484# VDD PMOS_S_26075639_X3_Y2_1774869254
XSCM_NMOS_72619132_X7_Y1_1774869255_0 IB m1_1860_3164# VSS SCM_NMOS_72619132_X7_Y1_1774869255
XNMOS_4T_1818045_X10_Y1_1774869251_0 m1_1258_2828# VIN m1_1860_3164# VSS NMOS_4T_1818045_X10_Y1_1774869251
XNMOS_4T_1818045_X10_Y1_1774869251_1 m1_2806_2828# VIP m1_1860_3164# VSS NMOS_4T_1818045_X10_Y1_1774869251
XNMOS_4T_97331930_X4_Y1_1774869252_0 VOUT VCN m1_1258_2828# VSS NMOS_4T_97331930_X4_Y1_1774869252
XPMOS_4T_28463424_X4_Y1_1774869253_0 VOUT VCP m1_656_1316# VDD PMOS_4T_28463424_X4_Y1_1774869253
XNMOS_4T_97331930_X4_Y1_1774869252_1 m1_570_1484# VCN m1_2806_2828# VSS NMOS_4T_97331930_X4_Y1_1774869252
XPMOS_4T_28463424_X4_Y1_1774869253_1 m1_570_1484# VCP m1_2924_1316# VDD PMOS_4T_28463424_X4_Y1_1774869253
.ends
