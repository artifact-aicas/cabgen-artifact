* NGSPICE file created from TELESCOPIC_OTA_0.ext - technology: sky130A

.subckt NMOS_4T_59553155_X8_Y1_1774869285 a_230_441# a_200_252# a_147_441# a_241_1232#
X0 a_147_441# a_200_252# a_230_441# a_241_1232# sky130_fd_pr__nfet_01v8 ad=0.1764 pd=1.54 as=0.1764 ps=1.54 w=1.26 l=0.15 M=16
.ends

.subckt NMOS_4T_93111016_X2_Y1_1774869286 a_230_441# a_200_252# a_147_441# a_241_1232#
X0 a_230_441# a_200_252# a_147_441# a_241_1232# sky130_fd_pr__nfet_01v8 ad=0.1764 pd=1.54 as=0.3339 ps=3.05 w=1.26 l=0.15 M=4
.ends

.subckt PMOS_4T_51289427_X7_Y1_1774869287 a_230_441# a_200_252# a_147_441# w_0_0#
X0 a_147_441# a_200_252# a_230_441# w_0_0# sky130_fd_pr__pfet_01v8 ad=0.1764 pd=1.54 as=0.1764 ps=1.54 w=1.26 l=0.15 M=14
.ends

.subckt PMOS_S_86315193_X6_Y1_1774869288 a_230_441# a_200_252# w_0_0#
X0 w_0_0# a_200_252# a_230_441# w_0_0# sky130_fd_pr__pfet_01v8 ad=0.1764 pd=1.54 as=0.1764 ps=1.54 w=1.26 l=0.15 M=12
.ends

.subckt SCM_NMOS_49597334_X4_Y1_1774869289 a_402_441# a_200_252# a_147_441#
X0 a_147_441# a_200_252# a_200_252# a_147_441# sky130_fd_pr__nfet_01v8 ad=0.1764 pd=1.54 as=0.1764 ps=1.54 w=1.26 l=0.15 M=8
X1 a_147_441# a_200_252# a_402_441# a_147_441# sky130_fd_pr__nfet_01v8 ad=0.1764 pd=1.54 as=0.1764 ps=1.54 w=1.26 l=0.15 M=8
.ends

.subckt TELESCOPIC_OTA_0 IB VCN VOUT VIP VIN VCP VSS VDD
XNMOS_4T_59553155_X8_Y1_1774869285_0 VOUT VCN m1_1946_1400# VSS NMOS_4T_59553155_X8_Y1_1774869285
XNMOS_4T_59553155_X8_Y1_1774869285_1 m1_5042_1400# VCN m1_4182_1400# VSS NMOS_4T_59553155_X8_Y1_1774869285
XNMOS_4T_93111016_X2_Y1_1774869286_0 m1_1946_1400# VIN m1_3526_1316# VSS NMOS_4T_93111016_X2_Y1_1774869286
XPMOS_4T_51289427_X7_Y1_1774869287_0 VOUT VCP m1_656_1316# VDD PMOS_4T_51289427_X7_Y1_1774869287
XNMOS_4T_93111016_X2_Y1_1774869286_1 m1_4182_1400# VIP m1_3526_1316# VSS NMOS_4T_93111016_X2_Y1_1774869286
XPMOS_4T_51289427_X7_Y1_1774869287_1 m1_5042_1400# VCP m1_5386_1316# VDD PMOS_4T_51289427_X7_Y1_1774869287
XPMOS_S_86315193_X6_Y1_1774869288_0 m1_656_1316# m1_5042_1400# VDD PMOS_S_86315193_X6_Y1_1774869288
XPMOS_S_86315193_X6_Y1_1774869288_1 m1_5386_1316# m1_5042_1400# VDD PMOS_S_86315193_X6_Y1_1774869288
XSCM_NMOS_49597334_X4_Y1_1774869289_0 m1_3526_1316# IB VSS SCM_NMOS_49597334_X4_Y1_1774869289
.ends
