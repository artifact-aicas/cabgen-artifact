* NGSPICE file created from TELESCOPIC_OTA_0.ext - technology: sky130A

.subckt NMOS_4T_59553155_X8_Y1_1774869285 a_230_441# a_200_252# a_147_441# a_241_1232#
X0 a_147_441# a_200_252# a_230_441# a_241_1232# sky130_fd_pr__nfet_01v8 ad=0.1764 pd=1.54 as=0.1764 ps=1.54 w=1.26 l=0.15
X1 a_147_441# a_200_252# a_230_441# a_241_1232# sky130_fd_pr__nfet_01v8 ad=0.1764 pd=1.54 as=0.1764 ps=1.54 w=1.26 l=0.15
X2 a_230_441# a_200_252# a_147_441# a_241_1232# sky130_fd_pr__nfet_01v8 ad=0.1764 pd=1.54 as=0.3339 ps=3.05 w=1.26 l=0.15
X3 a_147_441# a_200_252# a_230_441# a_241_1232# sky130_fd_pr__nfet_01v8 ad=0.1764 pd=1.54 as=0.1764 ps=1.54 w=1.26 l=0.15
X4 a_147_441# a_200_252# a_230_441# a_241_1232# sky130_fd_pr__nfet_01v8 ad=0.1764 pd=1.54 as=0.1764 ps=1.54 w=1.26 l=0.15
X5 a_230_441# a_200_252# a_147_441# a_241_1232# sky130_fd_pr__nfet_01v8 ad=0.1764 pd=1.54 as=0.1764 ps=1.54 w=1.26 l=0.15
X6 a_230_441# a_200_252# a_147_441# a_241_1232# sky130_fd_pr__nfet_01v8 ad=0.1764 pd=1.54 as=0.1764 ps=1.54 w=1.26 l=0.15
X7 a_147_441# a_200_252# a_230_441# a_241_1232# sky130_fd_pr__nfet_01v8 ad=0.3339 pd=3.05 as=0.1764 ps=1.54 w=1.26 l=0.15
X8 a_230_441# a_200_252# a_147_441# a_241_1232# sky130_fd_pr__nfet_01v8 ad=0.1764 pd=1.54 as=0.1764 ps=1.54 w=1.26 l=0.15
X9 a_230_441# a_200_252# a_147_441# a_241_1232# sky130_fd_pr__nfet_01v8 ad=0.1764 pd=1.54 as=0.1764 ps=1.54 w=1.26 l=0.15
X10 a_147_441# a_200_252# a_230_441# a_241_1232# sky130_fd_pr__nfet_01v8 ad=0.1764 pd=1.54 as=0.1764 ps=1.54 w=1.26 l=0.15
X11 a_147_441# a_200_252# a_230_441# a_241_1232# sky130_fd_pr__nfet_01v8 ad=0.1764 pd=1.54 as=0.1764 ps=1.54 w=1.26 l=0.15
X12 a_147_441# a_200_252# a_230_441# a_241_1232# sky130_fd_pr__nfet_01v8 ad=0.1764 pd=1.54 as=0.1764 ps=1.54 w=1.26 l=0.15
X13 a_230_441# a_200_252# a_147_441# a_241_1232# sky130_fd_pr__nfet_01v8 ad=0.1764 pd=1.54 as=0.1764 ps=1.54 w=1.26 l=0.15
X14 a_230_441# a_200_252# a_147_441# a_241_1232# sky130_fd_pr__nfet_01v8 ad=0.1764 pd=1.54 as=0.1764 ps=1.54 w=1.26 l=0.15
X15 a_230_441# a_200_252# a_147_441# a_241_1232# sky130_fd_pr__nfet_01v8 ad=0.1764 pd=1.54 as=0.1764 ps=1.54 w=1.26 l=0.15
C0 a_147_441# a_230_441# 5.57787f
C1 a_200_252# a_147_441# 0.720724f
C2 a_200_252# a_230_441# 0.718508f
C3 a_230_441# a_241_1232# 0.630141f
C4 a_147_441# a_241_1232# 0.822776f
C5 a_200_252# a_241_1232# 3.49147f
.ends

.subckt NMOS_4T_93111016_X2_Y1_1774869286 a_230_441# a_200_252# a_147_441# a_241_1232#
X0 a_230_441# a_200_252# a_147_441# a_241_1232# sky130_fd_pr__nfet_01v8 ad=0.1764 pd=1.54 as=0.3339 ps=3.05 w=1.26 l=0.15
X1 a_147_441# a_200_252# a_230_441# a_241_1232# sky130_fd_pr__nfet_01v8 ad=0.1764 pd=1.54 as=0.1764 ps=1.54 w=1.26 l=0.15
X2 a_230_441# a_200_252# a_147_441# a_241_1232# sky130_fd_pr__nfet_01v8 ad=0.1764 pd=1.54 as=0.1764 ps=1.54 w=1.26 l=0.15
X3 a_147_441# a_200_252# a_230_441# a_241_1232# sky130_fd_pr__nfet_01v8 ad=0.3339 pd=3.05 as=0.1764 ps=1.54 w=1.26 l=0.15
C0 a_147_441# a_230_441# 1.3461f
C1 a_200_252# a_147_441# 0.171288f
C2 a_200_252# a_230_441# 0.17932f
C3 a_230_441# a_241_1232# 0.155545f
C4 a_147_441# a_241_1232# 0.502549f
C5 a_200_252# a_241_1232# 1.03922f
.ends

.subckt PMOS_4T_51289427_X7_Y1_1774869287 a_230_441# a_200_252# a_147_441# w_0_0#
+ VSUBS
X0 a_147_441# a_200_252# a_230_441# w_0_0# sky130_fd_pr__pfet_01v8 ad=0.1764 pd=1.54 as=0.1764 ps=1.54 w=1.26 l=0.15
X1 a_147_441# a_200_252# a_230_441# w_0_0# sky130_fd_pr__pfet_01v8 ad=0.1764 pd=1.54 as=0.1764 ps=1.54 w=1.26 l=0.15
X2 a_230_441# a_200_252# a_147_441# w_0_0# sky130_fd_pr__pfet_01v8 ad=0.1764 pd=1.54 as=0.1764 ps=1.54 w=1.26 l=0.15
X3 a_230_441# a_200_252# a_147_441# w_0_0# sky130_fd_pr__pfet_01v8 ad=0.1764 pd=1.54 as=0.1764 ps=1.54 w=1.26 l=0.15
X4 a_230_441# a_200_252# a_147_441# w_0_0# sky130_fd_pr__pfet_01v8 ad=0.1764 pd=1.54 as=0.1764 ps=1.54 w=1.26 l=0.15
X5 a_147_441# a_200_252# a_230_441# w_0_0# sky130_fd_pr__pfet_01v8 ad=0.1764 pd=1.54 as=0.1764 ps=1.54 w=1.26 l=0.15
X6 a_147_441# a_200_252# a_230_441# w_0_0# sky130_fd_pr__pfet_01v8 ad=0.1764 pd=1.54 as=0.1764 ps=1.54 w=1.26 l=0.15
X7 a_147_441# a_200_252# a_230_441# w_0_0# sky130_fd_pr__pfet_01v8 ad=0.1764 pd=1.54 as=0.1764 ps=1.54 w=1.26 l=0.15
X8 a_230_441# a_200_252# a_147_441# w_0_0# sky130_fd_pr__pfet_01v8 ad=0.1764 pd=1.54 as=0.1764 ps=1.54 w=1.26 l=0.15
X9 a_230_441# a_200_252# a_147_441# w_0_0# sky130_fd_pr__pfet_01v8 ad=0.1764 pd=1.54 as=0.1764 ps=1.54 w=1.26 l=0.15
X10 a_230_441# a_200_252# a_147_441# w_0_0# sky130_fd_pr__pfet_01v8 ad=0.1764 pd=1.54 as=0.1764 ps=1.54 w=1.26 l=0.15
X11 a_147_441# a_200_252# a_230_441# w_0_0# sky130_fd_pr__pfet_01v8 ad=0.1764 pd=1.54 as=0.1764 ps=1.54 w=1.26 l=0.15
X12 a_147_441# a_200_252# a_230_441# w_0_0# sky130_fd_pr__pfet_01v8 ad=0.3339 pd=3.05 as=0.1764 ps=1.54 w=1.26 l=0.15
X13 a_230_441# a_200_252# a_147_441# w_0_0# sky130_fd_pr__pfet_01v8 ad=0.1764 pd=1.54 as=0.3339 ps=3.05 w=1.26 l=0.15
C0 a_230_441# a_200_252# 0.628643f
C1 a_200_252# a_147_441# 0.629151f
C2 a_230_441# a_147_441# 4.87258f
C3 w_0_0# a_200_252# 2.66385f
C4 w_0_0# a_230_441# 0.265428f
C5 w_0_0# a_147_441# 0.452644f
C6 a_230_441# VSUBS 0.285614f
C7 a_147_441# VSUBS 0.316761f
C8 a_200_252# VSUBS 0.418957f
C9 w_0_0# VSUBS 7.2786f
.ends

.subckt PMOS_S_86315193_X6_Y1_1774869288 a_230_441# a_200_252# w_0_0# VSUBS
X0 w_0_0# a_200_252# a_230_441# w_0_0# sky130_fd_pr__pfet_01v8 ad=0.1764 pd=1.54 as=0.1764 ps=1.54 w=1.26 l=0.15
X1 w_0_0# a_200_252# a_230_441# w_0_0# sky130_fd_pr__pfet_01v8 ad=0.1764 pd=1.54 as=0.1764 ps=1.54 w=1.26 l=0.15
X2 a_230_441# a_200_252# w_0_0# w_0_0# sky130_fd_pr__pfet_01v8 ad=0.1764 pd=1.54 as=0.1764 ps=1.54 w=1.26 l=0.15
X3 a_230_441# a_200_252# w_0_0# w_0_0# sky130_fd_pr__pfet_01v8 ad=0.1764 pd=1.54 as=0.1764 ps=1.54 w=1.26 l=0.15
X4 a_230_441# a_200_252# w_0_0# w_0_0# sky130_fd_pr__pfet_01v8 ad=0.1764 pd=1.54 as=0.1764 ps=1.54 w=1.26 l=0.15
X5 w_0_0# a_200_252# a_230_441# w_0_0# sky130_fd_pr__pfet_01v8 ad=0.3339 pd=3.05 as=0.1764 ps=1.54 w=1.26 l=0.15
X6 w_0_0# a_200_252# a_230_441# w_0_0# sky130_fd_pr__pfet_01v8 ad=0.1764 pd=1.54 as=0.1764 ps=1.54 w=1.26 l=0.15
X7 w_0_0# a_200_252# a_230_441# w_0_0# sky130_fd_pr__pfet_01v8 ad=0.1764 pd=1.54 as=0.1764 ps=1.54 w=1.26 l=0.15
X8 a_230_441# a_200_252# w_0_0# w_0_0# sky130_fd_pr__pfet_01v8 ad=0.1764 pd=1.54 as=0.1764 ps=1.54 w=1.26 l=0.15
X9 a_230_441# a_200_252# w_0_0# w_0_0# sky130_fd_pr__pfet_01v8 ad=0.1764 pd=1.54 as=0.1764 ps=1.54 w=1.26 l=0.15
X10 w_0_0# a_200_252# a_230_441# w_0_0# sky130_fd_pr__pfet_01v8 ad=0.1764 pd=1.54 as=0.1764 ps=1.54 w=1.26 l=0.15
X11 a_230_441# a_200_252# w_0_0# w_0_0# sky130_fd_pr__pfet_01v8 ad=0.1764 pd=1.54 as=0.3339 ps=3.05 w=1.26 l=0.15
C0 a_200_252# a_230_441# 0.538779f
C1 w_0_0# a_200_252# 2.98076f
C2 w_0_0# a_230_441# 4.47515f
C3 a_230_441# VSUBS 0.244237f
C4 a_200_252# VSUBS 0.377589f
C5 w_0_0# VSUBS 6.60734f
.ends

.subckt SCM_NMOS_49597334_X4_Y1_1774869289 a_402_441# a_200_252# a_147_441#
X0 a_147_441# a_200_252# a_200_252# a_147_441# sky130_fd_pr__nfet_01v8 ad=0.1764 pd=1.54 as=0.1764 ps=1.54 w=1.26 l=0.15
X1 a_147_441# a_200_252# a_402_441# a_147_441# sky130_fd_pr__nfet_01v8 ad=0.1764 pd=1.54 as=0.1764 ps=1.54 w=1.26 l=0.15
X2 a_200_252# a_200_252# a_147_441# a_147_441# sky130_fd_pr__nfet_01v8 ad=0.1764 pd=1.54 as=0.3339 ps=3.05 w=1.26 l=0.15
X3 a_147_441# a_200_252# a_200_252# a_147_441# sky130_fd_pr__nfet_01v8 ad=0.1764 pd=1.54 as=0.1764 ps=1.54 w=1.26 l=0.15
X4 a_147_441# a_200_252# a_402_441# a_147_441# sky130_fd_pr__nfet_01v8 ad=0.1764 pd=1.54 as=0.1764 ps=1.54 w=1.26 l=0.15
X5 a_402_441# a_200_252# a_147_441# a_147_441# sky130_fd_pr__nfet_01v8 ad=0.1764 pd=1.54 as=0.1764 ps=1.54 w=1.26 l=0.15
X6 a_200_252# a_200_252# a_147_441# a_147_441# sky130_fd_pr__nfet_01v8 ad=0.1764 pd=1.54 as=0.1764 ps=1.54 w=1.26 l=0.15
X7 a_147_441# a_200_252# a_200_252# a_147_441# sky130_fd_pr__nfet_01v8 ad=0.3339 pd=3.05 as=0.1764 ps=1.54 w=1.26 l=0.15
X8 a_402_441# a_200_252# a_147_441# a_147_441# sky130_fd_pr__nfet_01v8 ad=0.1764 pd=1.54 as=0.1764 ps=1.54 w=1.26 l=0.15
X9 a_200_252# a_200_252# a_147_441# a_147_441# sky130_fd_pr__nfet_01v8 ad=0.1764 pd=1.54 as=0.1764 ps=1.54 w=1.26 l=0.15
X10 a_147_441# a_200_252# a_402_441# a_147_441# sky130_fd_pr__nfet_01v8 ad=0.1764 pd=1.54 as=0.1764 ps=1.54 w=1.26 l=0.15
X11 a_147_441# a_200_252# a_402_441# a_147_441# sky130_fd_pr__nfet_01v8 ad=0.1764 pd=1.54 as=0.1764 ps=1.54 w=1.26 l=0.15
X12 a_147_441# a_200_252# a_200_252# a_147_441# sky130_fd_pr__nfet_01v8 ad=0.1764 pd=1.54 as=0.1764 ps=1.54 w=1.26 l=0.15
X13 a_200_252# a_200_252# a_147_441# a_147_441# sky130_fd_pr__nfet_01v8 ad=0.1764 pd=1.54 as=0.1764 ps=1.54 w=1.26 l=0.15
X14 a_402_441# a_200_252# a_147_441# a_147_441# sky130_fd_pr__nfet_01v8 ad=0.1764 pd=1.54 as=0.1764 ps=1.54 w=1.26 l=0.15
X15 a_402_441# a_200_252# a_147_441# a_147_441# sky130_fd_pr__nfet_01v8 ad=0.1764 pd=1.54 as=0.1764 ps=1.54 w=1.26 l=0.15
C0 a_200_252# a_402_441# 1.05008f
C1 a_402_441# a_147_441# 3.22831f
C2 a_200_252# a_147_441# 7.90696f
.ends

.subckt TELESCOPIC_OTA_0 IB VCN VOUT VIP VIN VCP VSS VDD
XNMOS_4T_59553155_X8_Y1_1774869285_0 VOUT VCN m1_1946_1400# VSS NMOS_4T_59553155_X8_Y1_1774869285
XNMOS_4T_59553155_X8_Y1_1774869285_1 m1_5042_1400# VCN m1_4182_1400# VSS NMOS_4T_59553155_X8_Y1_1774869285
XNMOS_4T_93111016_X2_Y1_1774869286_0 m1_1946_1400# VIN m1_3526_1316# VSS NMOS_4T_93111016_X2_Y1_1774869286
XPMOS_4T_51289427_X7_Y1_1774869287_0 VOUT VCP m1_656_1316# VDD VSS PMOS_4T_51289427_X7_Y1_1774869287
XNMOS_4T_93111016_X2_Y1_1774869286_1 m1_4182_1400# VIP m1_3526_1316# VSS NMOS_4T_93111016_X2_Y1_1774869286
XPMOS_4T_51289427_X7_Y1_1774869287_1 m1_5042_1400# VCP m1_5386_1316# VDD VSS PMOS_4T_51289427_X7_Y1_1774869287
XPMOS_S_86315193_X6_Y1_1774869288_0 m1_656_1316# m1_5042_1400# VDD VSS PMOS_S_86315193_X6_Y1_1774869288
XPMOS_S_86315193_X6_Y1_1774869288_1 m1_5386_1316# m1_5042_1400# VDD VSS PMOS_S_86315193_X6_Y1_1774869288
XSCM_NMOS_49597334_X4_Y1_1774869289_0 m1_3526_1316# IB VSS SCM_NMOS_49597334_X4_Y1_1774869289
R0 VCN.n23 VCN.t2 568.582
R1 VCN.n23 VCN.t3 568.582
R2 VCN.n24 VCN.t8 568.582
R3 VCN.n24 VCN.t11 568.582
R4 VCN.n26 VCN.t15 568.582
R5 VCN.n26 VCN.t4 568.582
R6 VCN.n28 VCN.t9 568.582
R7 VCN.n28 VCN.t12 568.582
R8 VCN.n21 VCN.t13 568.582
R9 VCN.n21 VCN.t0 568.582
R10 VCN.n19 VCN.t5 568.582
R11 VCN.n19 VCN.t10 568.582
R12 VCN.n17 VCN.t14 568.582
R13 VCN.n17 VCN.t1 568.582
R14 VCN.n15 VCN.t6 568.582
R15 VCN.n15 VCN.t7 568.582
R16 VCN.n13 VCN.t23 568.582
R17 VCN.n13 VCN.t22 568.582
R18 VCN.n11 VCN.t17 568.582
R19 VCN.n11 VCN.t30 568.582
R20 VCN.n9 VCN.t26 568.582
R21 VCN.n9 VCN.t21 568.582
R22 VCN.n7 VCN.t16 568.582
R23 VCN.n7 VCN.t29 568.582
R24 VCN.n5 VCN.t28 568.582
R25 VCN.n5 VCN.t25 568.582
R26 VCN.n3 VCN.t20 568.582
R27 VCN.n3 VCN.t31 568.582
R28 VCN.n1 VCN.t27 568.582
R29 VCN.n1 VCN.t24 568.582
R30 VCN.n0 VCN.t19 568.582
R31 VCN.n0 VCN.t18 568.582
R32 VCN.n25 VCN.n23 161.685
R33 VCN.n2 VCN.n0 161.685
R34 VCN.n25 VCN.n24 161.3
R35 VCN.n27 VCN.n26 161.3
R36 VCN.n29 VCN.n28 161.3
R37 VCN.n22 VCN.n21 161.3
R38 VCN.n20 VCN.n19 161.3
R39 VCN.n18 VCN.n17 161.3
R40 VCN.n16 VCN.n15 161.3
R41 VCN.n14 VCN.n13 161.3
R42 VCN.n12 VCN.n11 161.3
R43 VCN.n10 VCN.n9 161.3
R44 VCN.n8 VCN.n7 161.3
R45 VCN.n6 VCN.n5 161.3
R46 VCN.n4 VCN.n3 161.3
R47 VCN.n2 VCN.n1 161.3
R48 VCN.n16 VCN.n14 1.15229
R49 VCN.n4 VCN.n2 0.384429
R50 VCN.n6 VCN.n4 0.384429
R51 VCN.n8 VCN.n6 0.384429
R52 VCN.n10 VCN.n8 0.384429
R53 VCN.n12 VCN.n10 0.384429
R54 VCN.n14 VCN.n12 0.384429
R55 VCN.n18 VCN.n16 0.384429
R56 VCN.n20 VCN.n18 0.384429
R57 VCN.n22 VCN.n20 0.384429
R58 VCN.n29 VCN.n27 0.384429
R59 VCN.n27 VCN.n25 0.384429
R60 VCN VCN.n22 0.192464
R61 VCN VCN.n29 0.192464
R62 VSS.n9 VSS.n8 1179.49
R63 VSS.n9 VSS.n3 1179.3
R64 VSS.n4 VSS.n2 1179.3
R65 VSS.n7 VSS.n6 763.729
R66 VSS.n5 VSS.n3 535.494
R67 VSS.n10 VSS.n9 532.793
R68 VSS.n6 VSS.n5 432.863
R69 VSS.n11 VSS.n10 419.151
R70 VSS.n9 VSS.n2 240.867
R71 VSS.n10 VSS.n1 143.781
R72 VSS.n5 VSS.n2 109.258
R73 VSS.n6 VSS.n4 107.663
R74 VSS.n8 VSS.n7 10.348
R75 VSS.n1 VSS 7.5005
R76 VSS VSS.n0 3.973
R77 VSS VSS.n11 3.58615
R78 VSS.n3 VSS.n1 0.384429
R79 VSS.n11 VSS.n0 0.239612
R80 VSS.n8 VSS.n4 0.192464
R81 VSS.n7 VSS.n0 0.0762875
R82 VIN.n1 VIN.t1 568.582
R83 VIN.n1 VIN.t0 568.582
R84 VIN.n0 VIN.t3 568.582
R85 VIN.n0 VIN.t2 568.582
R86 VIN VIN.n1 161.493
R87 VIN VIN.n0 161.493
R88 VCP.n39 VCP.t12 573.581
R89 VCP.n37 VCP.t9 573.581
R90 VCP.n44 VCP.t5 573.581
R91 VCP.n42 VCP.t2 573.581
R92 VCP.n50 VCP.t11 573.581
R93 VCP.n48 VCP.t8 573.581
R94 VCP.n34 VCP.t7 573.581
R95 VCP.n32 VCP.t4 573.581
R96 VCP.n28 VCP.t1 573.581
R97 VCP.n26 VCP.t10 573.581
R98 VCP.n22 VCP.t6 573.581
R99 VCP.n20 VCP.t3 573.581
R100 VCP.n16 VCP.t0 573.581
R101 VCP.n14 VCP.t13 573.581
R102 VCP.n11 VCP.t14 568.582
R103 VCP.n11 VCP.t27 568.582
R104 VCP.n9 VCP.t20 568.582
R105 VCP.n9 VCP.t17 568.582
R106 VCP.n7 VCP.t15 568.582
R107 VCP.n7 VCP.t24 568.582
R108 VCP.n5 VCP.t21 568.582
R109 VCP.n5 VCP.t18 568.582
R110 VCP.n3 VCP.t25 568.582
R111 VCP.n3 VCP.t22 568.582
R112 VCP.n1 VCP.t19 568.582
R113 VCP.n1 VCP.t16 568.582
R114 VCP.n0 VCP.t26 568.582
R115 VCP.n0 VCP.t23 568.582
R116 VCP.n46 VCP.n40 161.685
R117 VCP.n2 VCP.n0 161.685
R118 VCP.n46 VCP.n45 161.3
R119 VCP.n52 VCP.n51 161.3
R120 VCP VCP.n35 161.3
R121 VCP.n30 VCP.n29 161.3
R122 VCP.n24 VCP.n23 161.3
R123 VCP.n18 VCP.n17 161.3
R124 VCP.n12 VCP.n11 161.3
R125 VCP.n10 VCP.n9 161.3
R126 VCP.n8 VCP.n7 161.3
R127 VCP.n6 VCP.n5 161.3
R128 VCP.n4 VCP.n3 161.3
R129 VCP.n2 VCP.n1 161.3
R130 VCP.n18 VCP.n12 88.271
R131 VCP.n39 VCP.n38 33.7405
R132 VCP.n37 VCP.n36 33.7405
R133 VCP.n44 VCP.n43 33.7405
R134 VCP.n42 VCP.n41 33.7405
R135 VCP.n50 VCP.n49 33.7405
R136 VCP.n48 VCP.n47 33.7405
R137 VCP.n34 VCP.n33 33.7405
R138 VCP.n32 VCP.n31 33.7405
R139 VCP.n28 VCP.n27 33.7405
R140 VCP.n26 VCP.n25 33.7405
R141 VCP.n22 VCP.n21 33.7405
R142 VCP.n20 VCP.n19 33.7405
R143 VCP.n16 VCP.n15 33.7405
R144 VCP.n14 VCP.n13 33.7405
R145 VCP.n40 VCP.n37 24.9931
R146 VCP.n40 VCP.n39 24.9931
R147 VCP.n45 VCP.n42 24.9931
R148 VCP.n45 VCP.n44 24.9931
R149 VCP.n51 VCP.n48 24.9931
R150 VCP.n51 VCP.n50 24.9931
R151 VCP.n35 VCP.n32 24.9931
R152 VCP.n35 VCP.n34 24.9931
R153 VCP.n29 VCP.n26 24.9931
R154 VCP.n29 VCP.n28 24.9931
R155 VCP.n23 VCP.n20 24.9931
R156 VCP.n23 VCP.n22 24.9931
R157 VCP.n17 VCP.n14 24.9931
R158 VCP.n17 VCP.n16 24.9931
R159 VCP.n4 VCP.n2 0.384429
R160 VCP.n6 VCP.n4 0.384429
R161 VCP.n8 VCP.n6 0.384429
R162 VCP.n10 VCP.n8 0.384429
R163 VCP.n12 VCP.n10 0.384429
R164 VCP.n24 VCP.n18 0.384429
R165 VCP.n30 VCP.n24 0.384429
R166 VCP VCP.n30 0.384429
R167 VCP VCP.n52 0.384429
R168 VCP.n52 VCP.n46 0.384429
R169 VDD.n28 VDD.n27 1014.81
R170 VDD.n8 VDD.n7 379.685
R171 VDD.n9 VDD.n8 379.3
R172 VDD.n12 VDD.n3 379.3
R173 VDD.n16 VDD.n15 379.3
R174 VDD.n25 VDD.n24 379.3
R175 VDD.n23 VDD.n22 379.3
R176 VDD.n19 VDD.n0 379.3
R177 VDD.n6 VDD.n4 54.0349
R178 VDD.n11 VDD.n10 54.0349
R179 VDD.n14 VDD.n13 54.0349
R180 VDD.n17 VDD.n2 54.0349
R181 VDD.n21 VDD.n20 54.0349
R182 VDD.n7 VDD.n5 27.0177
R183 VDD.n7 VDD.n6 27.0177
R184 VDD.n9 VDD.n4 27.0177
R185 VDD.n10 VDD.n9 27.0177
R186 VDD.n12 VDD.n11 27.0177
R187 VDD.n13 VDD.n12 27.0177
R188 VDD.n15 VDD.n14 27.0177
R189 VDD.n15 VDD.n1 27.0177
R190 VDD.n27 VDD.n1 27.0177
R191 VDD.n27 VDD.n26 27.0177
R192 VDD.n26 VDD.n25 27.0177
R193 VDD.n25 VDD.n2 27.0177
R194 VDD.n22 VDD.n17 27.0177
R195 VDD.n22 VDD.n21 27.0177
R196 VDD.n20 VDD.n19 27.0177
R197 VDD.n19 VDD.n18 27.0177
R198 VDD.n29 VDD 12.0934
R199 VDD.n28 VDD.n0 8.36129
R200 VDD VDD.n29 3.58615
R201 VDD.n29 VDD.n28 1.24012
R202 VDD.n8 VDD.n3 0.384429
R203 VDD.n16 VDD.n3 0.384429
R204 VDD.n24 VDD.n16 0.384429
R205 VDD.n24 VDD.n23 0.384429
R206 VDD.n23 VDD.n0 0.384429
R207 VIP.n1 VIP.t2 568.582
R208 VIP.n1 VIP.t3 568.582
R209 VIP.n0 VIP.t0 568.582
R210 VIP.n0 VIP.t1 568.582
R211 VIP VIP.n1 161.493
R212 VIP VIP.n0 161.493
R213 IB.n14 IB.t10 568.582
R214 IB.n14 IB.t12 568.582
R215 IB.n15 IB.t21 568.582
R216 IB.n15 IB.t19 568.582
R217 IB.n17 IB.t17 568.582
R218 IB.n17 IB.t23 568.582
R219 IB.n13 IB.t2 568.582
R220 IB.n13 IB.t4 568.582
R221 IB.n11 IB.t14 568.582
R222 IB.n11 IB.t0 568.582
R223 IB.n9 IB.t20 568.582
R224 IB.n9 IB.t18 568.582
R225 IB.n7 IB.t16 568.582
R226 IB.n7 IB.t22 568.582
R227 IB.n6 IB.t6 568.582
R228 IB.n6 IB.t8 568.582
R229 IB.n2 IB.n0 180.853
R230 IB.n5 IB.n4 180.852
R231 IB.n5 IB.n3 179.702
R232 IB.n2 IB.n1 179.702
R233 IB.n16 IB.n14 161.685
R234 IB.n8 IB.n6 161.685
R235 IB.n16 IB.n15 161.3
R236 IB.n18 IB.n17 161.3
R237 IB.n19 IB.n13 161.3
R238 IB.n12 IB.n11 161.3
R239 IB.n10 IB.n9 161.3
R240 IB.n8 IB.n7 161.3
R241 IB.n4 IB.t11 13.3338
R242 IB.n4 IB.t13 13.3338
R243 IB.n3 IB.t3 13.3338
R244 IB.n3 IB.t5 13.3338
R245 IB.n1 IB.t15 13.3338
R246 IB.n1 IB.t1 13.3338
R247 IB.n0 IB.t7 13.3338
R248 IB.n0 IB.t9 13.3338
R249 IB IB.n5 5.438
R250 IB IB.n19 5.438
R251 IB.n10 IB.n8 0.384429
R252 IB.n12 IB.n10 0.384429
R253 IB.n19 IB.n12 0.384429
R254 IB.n19 IB.n18 0.384429
R255 IB.n18 IB.n16 0.384429
R256 IB.n5 IB.n2 0.384429
C0 m1_1946_1400# IB 0.02875f
C1 m1_5042_1400# IB 0.161861f
C2 m1_1946_1400# VDD 0.03609f
C3 m1_5042_1400# VDD 0.786113f
C4 VIP VCP 0.250536f
C5 VIN IB 0.037154f
C6 VIN VDD 0.032517f
C7 m1_4182_1400# IB 0.024489f
C8 VCN m1_1946_1400# -0.141816f
C9 m1_5042_1400# VCN 0.368428f
C10 m1_4182_1400# VDD 0.134747f
C11 m1_656_1316# VDD 0.507544f
C12 m1_3526_1316# m1_1946_1400# 0.031965f
C13 VCN VIN 0.00381f
C14 m1_5042_1400# m1_3526_1316# 0.130787f
C15 VCN m1_4182_1400# -0.001516f
C16 VCP m1_1946_1400# 1.13e-19
C17 m1_5042_1400# VCP 0.039609f
C18 m1_4182_1400# m1_3526_1316# 0.03186f
C19 m1_656_1316# m1_3526_1316# 0.061102f
C20 VCP VIN 0.250536f
C21 VIP m1_5042_1400# 8.6e-19
C22 VDD m1_5386_1316# 0.571154f
C23 VCP m1_4182_1400# 1.13e-19
C24 VCP m1_656_1316# 0.013199f
C25 VOUT IB 0.12129f
C26 VIP m1_4182_1400# 8.32e-19
C27 VOUT VDD 0.29407f
C28 m1_3526_1316# m1_5386_1316# 0.063803f
C29 m1_5042_1400# m1_1946_1400# 1.306057f
C30 VCN VOUT -0.001065f
C31 VCP m1_5386_1316# 0.013788f
C32 m1_1946_1400# VIN 8.32e-19
C33 m1_5042_1400# VIN 1.43e-19
C34 VOUT m1_3526_1316# 0.120929f
C35 VDD IB 0.075105f
C36 m1_4182_1400# m1_1946_1400# 0.063575f
C37 m1_5042_1400# m1_4182_1400# 0.372567f
C38 VIP m1_5386_1316# 7.67e-19
C39 m1_656_1316# m1_1946_1400# 2.23e-20
C40 m1_5042_1400# m1_656_1316# 0.001775f
C41 VCP VOUT 0.014327f
C42 VCN IB 0.013242f
C43 m1_656_1316# VIN 7.67e-19
C44 VCN VDD 0.051699f
C45 m1_3526_1316# IB 0.229951f
C46 m1_3526_1316# VDD 0.113253f
C47 m1_5042_1400# m1_5386_1316# 0.55408f
C48 VCP IB 0.899736f
C49 VCP VDD 0.753806f
C50 VCN m1_3526_1316# 0.003361f
C51 VIP IB 0.034325f
C52 VIP VDD 0.048096f
C53 VOUT m1_1946_1400# 0.137635f
C54 m1_5042_1400# VOUT 0.281796f
C55 m1_4182_1400# m1_5386_1316# 2.79e-19
C56 VCN VCP 1.6e-19
C57 VOUT VIN 8.6e-19
C58 VCP m1_3526_1316# 0.062853f
C59 VIP VCN 0.00381f
C60 m1_4182_1400# VOUT 2.28e-19
C61 m1_656_1316# VOUT 0.435616f
C62 VCN VSS 7.383625f
C63 m1_5042_1400# VSS 2.472319f
C64 VCP VSS 2.220315f
C65 VOUT VSS 11.822811f
C66 VDD.n0 VSS 0.031891f
C67 VDD.n1 VSS 0.137483f
C68 VDD.n2 VSS 0.206224f
C69 VDD.n3 VSS 0.033347f
C70 VDD.n4 VSS 0.206224f
C71 VDD.n5 VSS 0.756155f
C72 VDD.n6 VSS 0.206224f
C73 VDD.n7 VSS 0.129784f
C74 VDD.n8 VSS 0.060508f
C75 VDD.n9 VSS 0.129756f
C76 VDD.n10 VSS 0.206224f
C77 VDD.n11 VSS 0.206224f
C78 VDD.n12 VSS 0.129756f
C79 VDD.n13 VSS 0.206224f
C80 VDD.n14 VSS 0.206224f
C81 VDD.n15 VSS 0.129756f
C82 VDD.n16 VSS 0.033347f
C83 VDD.n17 VSS 0.206224f
C84 VDD.n18 VSS 0.756155f
C85 VDD.n19 VSS 0.129756f
C86 VDD.n20 VSS 0.206224f
C87 VDD.n21 VSS 0.206224f
C88 VDD.n22 VSS 0.129756f
C89 VDD.n23 VSS 0.033347f
C90 VDD.n24 VSS 0.033347f
C91 VDD.n25 VSS 0.129756f
C92 VDD.n26 VSS 0.137483f
C93 VDD.n27 VSS 2.3204f
C94 VDD.n28 VSS 3.53887f
C95 VDD.n29 VSS 6.49271f
C96 VCP.t26 VSS 0.025467f
C97 VCP.t23 VSS 0.025467f
C98 VCP.n0 VSS 0.114443f
C99 VCP.t19 VSS 0.025467f
C100 VCP.t16 VSS 0.025467f
C101 VCP.n1 VSS 0.114165f
C102 VCP.n2 VSS 0.255224f
C103 VCP.t25 VSS 0.025467f
C104 VCP.t22 VSS 0.025467f
C105 VCP.n3 VSS 0.114165f
C106 VCP.n4 VSS 0.138264f
C107 VCP.t21 VSS 0.025467f
C108 VCP.t18 VSS 0.025467f
C109 VCP.n5 VSS 0.114165f
C110 VCP.n6 VSS 0.138264f
C111 VCP.t15 VSS 0.025467f
C112 VCP.t24 VSS 0.025467f
C113 VCP.n7 VSS 0.114165f
C114 VCP.n8 VSS 0.138264f
C115 VCP.t20 VSS 0.025467f
C116 VCP.t17 VSS 0.025467f
C117 VCP.n9 VSS 0.114165f
C118 VCP.n10 VSS 0.138264f
C119 VCP.t14 VSS 0.025467f
C120 VCP.t27 VSS 0.025467f
C121 VCP.n11 VSS 0.114165f
C122 VCP.n12 VSS 0.903803f
C123 VCP.t13 VSS 0.025018f
C124 VCP.n13 VSS 0.029567f
C125 VCP.n14 VSS 0.046397f
C126 VCP.t0 VSS 0.025018f
C127 VCP.n15 VSS 0.029567f
C128 VCP.n16 VSS 0.046397f
C129 VCP.n17 VSS 0.015121f
C130 VCP.n18 VSS 0.903803f
C131 VCP.t3 VSS 0.025018f
C132 VCP.n19 VSS 0.029567f
C133 VCP.n20 VSS 0.046397f
C134 VCP.t6 VSS 0.025018f
C135 VCP.n21 VSS 0.029567f
C136 VCP.n22 VSS 0.046397f
C137 VCP.n23 VSS 0.015121f
C138 VCP.n24 VSS 0.138264f
C139 VCP.t10 VSS 0.025018f
C140 VCP.n25 VSS 0.029567f
C141 VCP.n26 VSS 0.046397f
C142 VCP.t1 VSS 0.025018f
C143 VCP.n27 VSS 0.029567f
C144 VCP.n28 VSS 0.046397f
C145 VCP.n29 VSS 0.015121f
C146 VCP.n30 VSS 0.138264f
C147 VCP.t4 VSS 0.025018f
C148 VCP.n31 VSS 0.029567f
C149 VCP.n32 VSS 0.046397f
C150 VCP.t7 VSS 0.025018f
C151 VCP.n33 VSS 0.029567f
C152 VCP.n34 VSS 0.046397f
C153 VCP.n35 VSS 0.015121f
C154 VCP.t9 VSS 0.025018f
C155 VCP.n36 VSS 0.029567f
C156 VCP.n37 VSS 0.046397f
C157 VCP.t12 VSS 0.025018f
C158 VCP.n38 VSS 0.029567f
C159 VCP.n39 VSS 0.046397f
C160 VCP.n40 VSS 0.0154f
C161 VCP.t2 VSS 0.025018f
C162 VCP.n41 VSS 0.029567f
C163 VCP.n42 VSS 0.046397f
C164 VCP.t5 VSS 0.025018f
C165 VCP.n43 VSS 0.029567f
C166 VCP.n44 VSS 0.046397f
C167 VCP.n45 VSS 0.015121f
C168 VCP.n46 VSS 0.255224f
C169 VCP.t8 VSS 0.025018f
C170 VCP.n47 VSS 0.029567f
C171 VCP.n48 VSS 0.046397f
C172 VCP.t11 VSS 0.025018f
C173 VCP.n49 VSS 0.029567f
C174 VCP.n50 VSS 0.046397f
C175 VCP.n51 VSS 0.015121f
C176 VCP.n52 VSS 0.138264f
C177 IB VSS 7.46173f
C178 m1_5386_1316# VSS 0.308317f
C179 m1_4182_1400# VSS 1.352098f
C180 VIP VSS 0.977325f
C181 m1_656_1316# VSS 0.352558f
C182 VDD VSS 39.349674f
C183 m1_1946_1400# VSS 1.194502f
C184 m1_3526_1316# VSS 4.731381f
C185 VIN VSS 0.984556f
.ends
