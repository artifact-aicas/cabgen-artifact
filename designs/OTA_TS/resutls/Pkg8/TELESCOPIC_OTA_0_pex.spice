* NGSPICE file created from TELESCOPIC_OTA_0.ext - technology: sky130A

.subckt SCM_NMOS_21822889_X4_Y2_1774869491 a_230_1554# a_200_252# a_147_378#
X0 a_230_1554# a_200_252# a_147_378# a_147_378# sky130_fd_pr__nfet_01v8 ad=0.2646 pd=2.17 as=0.2646 ps=2.17 w=1.89 l=0.15
X1 a_147_378# a_200_252# a_200_252# a_147_378# sky130_fd_pr__nfet_01v8 ad=0.50085 pd=4.31 as=0.2646 ps=2.17 w=1.89 l=0.15
X2 a_200_252# a_200_252# a_147_378# a_147_378# sky130_fd_pr__nfet_01v8 ad=0.2646 pd=2.17 as=0.2646 ps=2.17 w=1.89 l=0.15
X3 a_230_1554# a_200_252# a_147_378# a_147_378# sky130_fd_pr__nfet_01v8 ad=0.2646 pd=2.17 as=0.2646 ps=2.17 w=1.89 l=0.15
X4 a_200_252# a_200_252# a_147_378# a_147_378# sky130_fd_pr__nfet_01v8 ad=0.2646 pd=2.17 as=0.2646 ps=2.17 w=1.89 l=0.15
X5 a_230_1554# a_200_252# a_147_378# a_147_378# sky130_fd_pr__nfet_01v8 ad=0.2646 pd=2.17 as=0.2646 ps=2.17 w=1.89 l=0.15
X6 a_147_378# a_200_252# a_200_252# a_147_378# sky130_fd_pr__nfet_01v8 ad=0.2646 pd=2.17 as=0.2646 ps=2.17 w=1.89 l=0.15
X7 a_147_378# a_200_252# a_200_252# a_147_378# sky130_fd_pr__nfet_01v8 ad=0.2646 pd=2.17 as=0.2646 ps=2.17 w=1.89 l=0.15
X8 a_147_378# a_200_252# a_230_1554# a_147_378# sky130_fd_pr__nfet_01v8 ad=0.2646 pd=2.17 as=0.2646 ps=2.17 w=1.89 l=0.15
X9 a_230_1554# a_200_252# a_147_378# a_147_378# sky130_fd_pr__nfet_01v8 ad=0.2646 pd=2.17 as=0.50085 ps=4.31 w=1.89 l=0.15
X10 a_200_252# a_200_252# a_147_378# a_147_378# sky130_fd_pr__nfet_01v8 ad=0.2646 pd=2.17 as=0.2646 ps=2.17 w=1.89 l=0.15
X11 a_147_378# a_200_252# a_230_1554# a_147_378# sky130_fd_pr__nfet_01v8 ad=0.2646 pd=2.17 as=0.2646 ps=2.17 w=1.89 l=0.15
X12 a_147_378# a_200_252# a_200_252# a_147_378# sky130_fd_pr__nfet_01v8 ad=0.2646 pd=2.17 as=0.2646 ps=2.17 w=1.89 l=0.15
X13 a_230_1554# a_200_252# a_147_378# a_147_378# sky130_fd_pr__nfet_01v8 ad=0.2646 pd=2.17 as=0.2646 ps=2.17 w=1.89 l=0.15
X14 a_147_378# a_200_252# a_230_1554# a_147_378# sky130_fd_pr__nfet_01v8 ad=0.2646 pd=2.17 as=0.2646 ps=2.17 w=1.89 l=0.15
X15 a_230_1554# a_200_252# a_147_378# a_147_378# sky130_fd_pr__nfet_01v8 ad=0.2646 pd=2.17 as=0.2646 ps=2.17 w=1.89 l=0.15
X16 a_147_378# a_200_252# a_230_1554# a_147_378# sky130_fd_pr__nfet_01v8 ad=0.2646 pd=2.17 as=0.2646 ps=2.17 w=1.89 l=0.15
X17 a_147_378# a_200_252# a_200_252# a_147_378# sky130_fd_pr__nfet_01v8 ad=0.2646 pd=2.17 as=0.2646 ps=2.17 w=1.89 l=0.15
X18 a_200_252# a_200_252# a_147_378# a_147_378# sky130_fd_pr__nfet_01v8 ad=0.2646 pd=2.17 as=0.2646 ps=2.17 w=1.89 l=0.15
X19 a_147_378# a_200_252# a_200_252# a_147_378# sky130_fd_pr__nfet_01v8 ad=0.2646 pd=2.17 as=0.2646 ps=2.17 w=1.89 l=0.15
X20 a_200_252# a_200_252# a_147_378# a_147_378# sky130_fd_pr__nfet_01v8 ad=0.2646 pd=2.17 as=0.2646 ps=2.17 w=1.89 l=0.15
X21 a_200_252# a_200_252# a_147_378# a_147_378# sky130_fd_pr__nfet_01v8 ad=0.2646 pd=2.17 as=0.2646 ps=2.17 w=1.89 l=0.15
X22 a_147_378# a_200_252# a_230_1554# a_147_378# sky130_fd_pr__nfet_01v8 ad=0.2646 pd=2.17 as=0.2646 ps=2.17 w=1.89 l=0.15
X23 a_200_252# a_200_252# a_147_378# a_147_378# sky130_fd_pr__nfet_01v8 ad=0.2646 pd=2.17 as=0.2646 ps=2.17 w=1.89 l=0.15
X24 a_230_1554# a_200_252# a_147_378# a_147_378# sky130_fd_pr__nfet_01v8 ad=0.2646 pd=2.17 as=0.2646 ps=2.17 w=1.89 l=0.15
X25 a_230_1554# a_200_252# a_147_378# a_147_378# sky130_fd_pr__nfet_01v8 ad=0.2646 pd=2.17 as=0.2646 ps=2.17 w=1.89 l=0.15
X26 a_147_378# a_200_252# a_230_1554# a_147_378# sky130_fd_pr__nfet_01v8 ad=0.50085 pd=4.31 as=0.2646 ps=2.17 w=1.89 l=0.15
X27 a_147_378# a_200_252# a_200_252# a_147_378# sky130_fd_pr__nfet_01v8 ad=0.2646 pd=2.17 as=0.2646 ps=2.17 w=1.89 l=0.15
X28 a_147_378# a_200_252# a_230_1554# a_147_378# sky130_fd_pr__nfet_01v8 ad=0.2646 pd=2.17 as=0.2646 ps=2.17 w=1.89 l=0.15
X29 a_200_252# a_200_252# a_147_378# a_147_378# sky130_fd_pr__nfet_01v8 ad=0.2646 pd=2.17 as=0.50085 ps=4.31 w=1.89 l=0.15
X30 a_147_378# a_200_252# a_200_252# a_147_378# sky130_fd_pr__nfet_01v8 ad=0.2646 pd=2.17 as=0.2646 ps=2.17 w=1.89 l=0.15
X31 a_147_378# a_200_252# a_230_1554# a_147_378# sky130_fd_pr__nfet_01v8 ad=0.2646 pd=2.17 as=0.2646 ps=2.17 w=1.89 l=0.15
C0 a_200_252# a_230_1554# 2.88923f
C1 a_230_1554# a_147_378# 7.48096f
C2 a_200_252# a_147_378# 13.6202f
.ends

.subckt PMOS_4T_59417588_X9_Y1_1774869489 a_200_252# a_230_378# w_0_0# a_147_378#
+ VSUBS
X0 a_230_378# a_200_252# a_147_378# w_0_0# sky130_fd_pr__pfet_01v8 ad=0.2646 pd=2.17 as=0.2646 ps=2.17 w=1.89 l=0.15
X1 a_230_378# a_200_252# a_147_378# w_0_0# sky130_fd_pr__pfet_01v8 ad=0.2646 pd=2.17 as=0.2646 ps=2.17 w=1.89 l=0.15
X2 a_147_378# a_200_252# a_230_378# w_0_0# sky130_fd_pr__pfet_01v8 ad=0.2646 pd=2.17 as=0.2646 ps=2.17 w=1.89 l=0.15
X3 a_230_378# a_200_252# a_147_378# w_0_0# sky130_fd_pr__pfet_01v8 ad=0.2646 pd=2.17 as=0.2646 ps=2.17 w=1.89 l=0.15
X4 a_147_378# a_200_252# a_230_378# w_0_0# sky130_fd_pr__pfet_01v8 ad=0.2646 pd=2.17 as=0.2646 ps=2.17 w=1.89 l=0.15
X5 a_147_378# a_200_252# a_230_378# w_0_0# sky130_fd_pr__pfet_01v8 ad=0.2646 pd=2.17 as=0.2646 ps=2.17 w=1.89 l=0.15
X6 a_230_378# a_200_252# a_147_378# w_0_0# sky130_fd_pr__pfet_01v8 ad=0.2646 pd=2.17 as=0.2646 ps=2.17 w=1.89 l=0.15
X7 a_230_378# a_200_252# a_147_378# w_0_0# sky130_fd_pr__pfet_01v8 ad=0.2646 pd=2.17 as=0.2646 ps=2.17 w=1.89 l=0.15
X8 a_147_378# a_200_252# a_230_378# w_0_0# sky130_fd_pr__pfet_01v8 ad=0.50085 pd=4.31 as=0.2646 ps=2.17 w=1.89 l=0.15
X9 a_230_378# a_200_252# a_147_378# w_0_0# sky130_fd_pr__pfet_01v8 ad=0.2646 pd=2.17 as=0.2646 ps=2.17 w=1.89 l=0.15
X10 a_147_378# a_200_252# a_230_378# w_0_0# sky130_fd_pr__pfet_01v8 ad=0.2646 pd=2.17 as=0.2646 ps=2.17 w=1.89 l=0.15
X11 a_147_378# a_200_252# a_230_378# w_0_0# sky130_fd_pr__pfet_01v8 ad=0.2646 pd=2.17 as=0.2646 ps=2.17 w=1.89 l=0.15
X12 a_230_378# a_200_252# a_147_378# w_0_0# sky130_fd_pr__pfet_01v8 ad=0.2646 pd=2.17 as=0.50085 ps=4.31 w=1.89 l=0.15
X13 a_147_378# a_200_252# a_230_378# w_0_0# sky130_fd_pr__pfet_01v8 ad=0.2646 pd=2.17 as=0.2646 ps=2.17 w=1.89 l=0.15
X14 a_147_378# a_200_252# a_230_378# w_0_0# sky130_fd_pr__pfet_01v8 ad=0.2646 pd=2.17 as=0.2646 ps=2.17 w=1.89 l=0.15
X15 a_230_378# a_200_252# a_147_378# w_0_0# sky130_fd_pr__pfet_01v8 ad=0.2646 pd=2.17 as=0.2646 ps=2.17 w=1.89 l=0.15
X16 a_230_378# a_200_252# a_147_378# w_0_0# sky130_fd_pr__pfet_01v8 ad=0.2646 pd=2.17 as=0.2646 ps=2.17 w=1.89 l=0.15
X17 a_147_378# a_200_252# a_230_378# w_0_0# sky130_fd_pr__pfet_01v8 ad=0.2646 pd=2.17 as=0.2646 ps=2.17 w=1.89 l=0.15
C0 a_230_378# a_147_378# 6.29481f
C1 a_147_378# a_200_252# 0.734841f
C2 w_0_0# a_147_378# 0.474832f
C3 a_230_378# a_200_252# 0.731095f
C4 w_0_0# a_230_378# 0.28197f
C5 w_0_0# a_200_252# 2.76113f
C6 a_230_378# VSUBS 0.368368f
C7 a_147_378# VSUBS 0.322332f
C8 a_200_252# VSUBS 0.482171f
C9 w_0_0# VSUBS 8.89989f
.ends

.subckt NMOS_4T_74585927_X2_Y1_1774869487 a_200_252# a_230_378# a_147_378# a_241_1232#
X0 a_230_378# a_200_252# a_147_378# a_241_1232# sky130_fd_pr__nfet_01v8 ad=0.2646 pd=2.17 as=0.2646 ps=2.17 w=1.89 l=0.15
X1 a_147_378# a_200_252# a_230_378# a_241_1232# sky130_fd_pr__nfet_01v8 ad=0.50085 pd=4.31 as=0.2646 ps=2.17 w=1.89 l=0.15
X2 a_230_378# a_200_252# a_147_378# a_241_1232# sky130_fd_pr__nfet_01v8 ad=0.2646 pd=2.17 as=0.50085 ps=4.31 w=1.89 l=0.15
X3 a_147_378# a_200_252# a_230_378# a_241_1232# sky130_fd_pr__nfet_01v8 ad=0.2646 pd=2.17 as=0.2646 ps=2.17 w=1.89 l=0.15
C0 a_230_378# a_147_378# 1.34869f
C1 a_200_252# a_230_378# 0.162147f
C2 a_200_252# a_147_378# 0.153937f
C3 a_230_378# a_241_1232# 0.142456f
C4 a_147_378# a_241_1232# 0.479554f
C5 a_200_252# a_241_1232# 0.857682f
.ends

.subckt NMOS_4T_96640015_X5_Y1_1774869488 a_200_252# a_230_378# a_147_378# a_241_1232#
X0 a_230_378# a_200_252# a_147_378# a_241_1232# sky130_fd_pr__nfet_01v8 ad=0.2646 pd=2.17 as=0.2646 ps=2.17 w=1.89 l=0.15
X1 a_230_378# a_200_252# a_147_378# a_241_1232# sky130_fd_pr__nfet_01v8 ad=0.2646 pd=2.17 as=0.2646 ps=2.17 w=1.89 l=0.15
X2 a_147_378# a_200_252# a_230_378# a_241_1232# sky130_fd_pr__nfet_01v8 ad=0.2646 pd=2.17 as=0.2646 ps=2.17 w=1.89 l=0.15
X3 a_147_378# a_200_252# a_230_378# a_241_1232# sky130_fd_pr__nfet_01v8 ad=0.2646 pd=2.17 as=0.2646 ps=2.17 w=1.89 l=0.15
X4 a_230_378# a_200_252# a_147_378# a_241_1232# sky130_fd_pr__nfet_01v8 ad=0.2646 pd=2.17 as=0.2646 ps=2.17 w=1.89 l=0.15
X5 a_230_378# a_200_252# a_147_378# a_241_1232# sky130_fd_pr__nfet_01v8 ad=0.2646 pd=2.17 as=0.2646 ps=2.17 w=1.89 l=0.15
X6 a_147_378# a_200_252# a_230_378# a_241_1232# sky130_fd_pr__nfet_01v8 ad=0.50085 pd=4.31 as=0.2646 ps=2.17 w=1.89 l=0.15
X7 a_230_378# a_200_252# a_147_378# a_241_1232# sky130_fd_pr__nfet_01v8 ad=0.2646 pd=2.17 as=0.50085 ps=4.31 w=1.89 l=0.15
X8 a_147_378# a_200_252# a_230_378# a_241_1232# sky130_fd_pr__nfet_01v8 ad=0.2646 pd=2.17 as=0.2646 ps=2.17 w=1.89 l=0.15
X9 a_147_378# a_200_252# a_230_378# a_241_1232# sky130_fd_pr__nfet_01v8 ad=0.2646 pd=2.17 as=0.2646 ps=2.17 w=1.89 l=0.15
C0 a_230_378# a_147_378# 3.46846f
C1 a_200_252# a_230_378# 0.405982f
C2 a_200_252# a_147_378# 0.402896f
C3 a_230_378# a_241_1232# 0.36012f
C4 a_147_378# a_241_1232# 0.615672f
C5 a_200_252# a_241_1232# 1.88007f
.ends

.subckt PMOS_S_72158034_X5_Y1_1774869490 a_200_252# a_230_378# w_0_0# VSUBS
X0 a_230_378# a_200_252# w_0_0# w_0_0# sky130_fd_pr__pfet_01v8 ad=0.2646 pd=2.17 as=0.2646 ps=2.17 w=1.89 l=0.15
X1 a_230_378# a_200_252# w_0_0# w_0_0# sky130_fd_pr__pfet_01v8 ad=0.2646 pd=2.17 as=0.2646 ps=2.17 w=1.89 l=0.15
X2 w_0_0# a_200_252# a_230_378# w_0_0# sky130_fd_pr__pfet_01v8 ad=0.2646 pd=2.17 as=0.2646 ps=2.17 w=1.89 l=0.15
X3 w_0_0# a_200_252# a_230_378# w_0_0# sky130_fd_pr__pfet_01v8 ad=0.2646 pd=2.17 as=0.2646 ps=2.17 w=1.89 l=0.15
X4 a_230_378# a_200_252# w_0_0# w_0_0# sky130_fd_pr__pfet_01v8 ad=0.2646 pd=2.17 as=0.2646 ps=2.17 w=1.89 l=0.15
X5 a_230_378# a_200_252# w_0_0# w_0_0# sky130_fd_pr__pfet_01v8 ad=0.2646 pd=2.17 as=0.2646 ps=2.17 w=1.89 l=0.15
X6 w_0_0# a_200_252# a_230_378# w_0_0# sky130_fd_pr__pfet_01v8 ad=0.50085 pd=4.31 as=0.2646 ps=2.17 w=1.89 l=0.15
X7 a_230_378# a_200_252# w_0_0# w_0_0# sky130_fd_pr__pfet_01v8 ad=0.2646 pd=2.17 as=0.50085 ps=4.31 w=1.89 l=0.15
X8 w_0_0# a_200_252# a_230_378# w_0_0# sky130_fd_pr__pfet_01v8 ad=0.2646 pd=2.17 as=0.2646 ps=2.17 w=1.89 l=0.15
X9 w_0_0# a_200_252# a_230_378# w_0_0# sky130_fd_pr__pfet_01v8 ad=0.2646 pd=2.17 as=0.2646 ps=2.17 w=1.89 l=0.15
C0 a_230_378# a_200_252# 0.405982f
C1 w_0_0# a_230_378# 3.68954f
C2 w_0_0# a_200_252# 2.10204f
C3 a_230_378# VSUBS 0.20286f
C4 a_200_252# VSUBS 0.3167f
C5 w_0_0# VSUBS 5.84923f
.ends

.subckt TELESCOPIC_OTA_0 IB VCN VOUT VIP VIN VCP VSS VDD
XSCM_NMOS_21822889_X4_Y2_1774869491_0 m1_4128_1316# IB VSS SCM_NMOS_21822889_X4_Y2_1774869491
XPMOS_4T_59417588_X9_Y1_1774869489_0 VCP VOUT VDD m1_2462_1316# VSS PMOS_4T_59417588_X9_Y1_1774869489
XNMOS_4T_74585927_X2_Y1_1774869487_0 VIN m1_3838_1400# m1_4128_1316# VSS NMOS_4T_74585927_X2_Y1_1774869487
XPMOS_4T_59417588_X9_Y1_1774869489_1 VCP m1_5730_1400# VDD m1_5902_1316# VSS PMOS_4T_59417588_X9_Y1_1774869489
XNMOS_4T_74585927_X2_Y1_1774869487_1 VIP m1_4698_1400# m1_4128_1316# VSS NMOS_4T_74585927_X2_Y1_1774869487
XNMOS_4T_96640015_X5_Y1_1774869488_0 VCN VOUT m1_3838_1400# VSS NMOS_4T_96640015_X5_Y1_1774869488
XNMOS_4T_96640015_X5_Y1_1774869488_1 VCN m1_5730_1400# m1_4698_1400# VSS NMOS_4T_96640015_X5_Y1_1774869488
XPMOS_S_72158034_X5_Y1_1774869490_1 m1_5730_1400# m1_5902_1316# VDD VSS PMOS_S_72158034_X5_Y1_1774869490
XPMOS_S_72158034_X5_Y1_1774869490_0 m1_5730_1400# m1_2462_1316# VDD VSS PMOS_S_72158034_X5_Y1_1774869490
R0 IB.n8 IB.t36 568.582
R1 IB.n8 IB.t39 568.582
R2 IB.n9 IB.t16 568.582
R3 IB.n9 IB.t24 568.582
R4 IB.n11 IB.t8 568.582
R5 IB.n11 IB.t18 568.582
R6 IB.n7 IB.t34 568.582
R7 IB.n7 IB.t37 568.582
R8 IB.n5 IB.t40 568.582
R9 IB.n5 IB.t42 568.582
R10 IB.n3 IB.t28 568.582
R11 IB.n3 IB.t12 568.582
R12 IB.n1 IB.t20 568.582
R13 IB.n1 IB.t10 568.582
R14 IB.n0 IB.t38 568.582
R15 IB.n0 IB.t45 568.582
R16 IB.n36 IB.t26 568.582
R17 IB.n36 IB.t0 568.582
R18 IB.n37 IB.t33 568.582
R19 IB.n37 IB.t41 568.582
R20 IB.n39 IB.t44 568.582
R21 IB.n39 IB.t47 568.582
R22 IB.n35 IB.t2 568.582
R23 IB.n35 IB.t4 568.582
R24 IB.n33 IB.t22 568.582
R25 IB.n33 IB.t6 568.582
R26 IB.n31 IB.t32 568.582
R27 IB.n31 IB.t35 568.582
R28 IB.n29 IB.t43 568.582
R29 IB.n29 IB.t46 568.582
R30 IB.n28 IB.t14 568.582
R31 IB.n28 IB.t30 568.582
R32 IB.n10 IB.n8 161.685
R33 IB.n2 IB.n0 161.685
R34 IB.n38 IB.n36 161.685
R35 IB.n30 IB.n28 161.685
R36 IB.n10 IB.n9 161.3
R37 IB.n12 IB.n11 161.3
R38 IB.n13 IB.n7 161.3
R39 IB.n6 IB.n5 161.3
R40 IB.n4 IB.n3 161.3
R41 IB.n2 IB.n1 161.3
R42 IB.n38 IB.n37 161.3
R43 IB.n40 IB.n39 161.3
R44 IB.n41 IB.n35 161.3
R45 IB.n34 IB.n33 161.3
R46 IB.n32 IB.n31 161.3
R47 IB.n30 IB.n29 161.3
R48 IB.n27 IB.n26 153.785
R49 IB.n24 IB.n22 153.785
R50 IB.n19 IB.n17 153.018
R51 IB.n16 IB.n14 153.018
R52 IB.n27 IB.n25 152.633
R53 IB.n24 IB.n23 152.633
R54 IB.n19 IB.n18 152.633
R55 IB.n16 IB.n15 152.633
R56 IB.n26 IB.t1 8.88939
R57 IB.n26 IB.t27 8.88939
R58 IB.n25 IB.t5 8.88939
R59 IB.n25 IB.t3 8.88939
R60 IB.n23 IB.t7 8.88939
R61 IB.n23 IB.t23 8.88939
R62 IB.n22 IB.t31 8.88939
R63 IB.n22 IB.t15 8.88939
R64 IB.n17 IB.t25 8.88939
R65 IB.n17 IB.t17 8.88939
R66 IB.n18 IB.t19 8.88939
R67 IB.n18 IB.t9 8.88939
R68 IB.n15 IB.t13 8.88939
R69 IB.n15 IB.t29 8.88939
R70 IB.n14 IB.t11 8.88939
R71 IB.n14 IB.t21 8.88939
R72 IB.n21 IB.n13 6.3755
R73 IB.n42 IB.n27 6.3755
R74 IB.n21 IB.n20 4.5005
R75 IB.n42 IB.n41 4.5005
R76 IB.n20 IB.n16 0.768357
R77 IB.n4 IB.n2 0.384429
R78 IB.n6 IB.n4 0.384429
R79 IB.n13 IB.n6 0.384429
R80 IB.n13 IB.n12 0.384429
R81 IB.n12 IB.n10 0.384429
R82 IB.n32 IB.n30 0.384429
R83 IB.n34 IB.n32 0.384429
R84 IB.n41 IB.n34 0.384429
R85 IB.n41 IB.n40 0.384429
R86 IB.n40 IB.n38 0.384429
R87 IB.n27 IB.n24 0.384429
R88 IB.n20 IB.n19 0.384429
R89 IB IB.n21 0.3755
R90 IB IB.n42 0.3755
R91 VSS.t10 VSS.n5 71576.1
R92 VSS.n5 VSS.n3 4297.67
R93 VSS.n3 VSS.n0 1322.5
R94 VSS VSS.n3 1317.08
R95 VSS.n7 VSS.n6 1179.68
R96 VSS.n12 VSS.n10 1179.68
R97 VSS.n8 VSS.n7 1179.3
R98 VSS.n9 VSS.n1 1179.3
R99 VSS.n17 VSS.n16 1179.3
R100 VSS.n15 VSS.n2 1179.3
R101 VSS.n14 VSS.n13 1179.3
R102 VSS.n12 VSS.n11 1179.3
R103 VSS.n5 VSS.n4 300.62
R104 VSS.t32 VSS.t6 120.433
R105 VSS.t34 VSS.t14 120.433
R106 VSS.t8 VSS.t16 120.433
R107 VSS.t21 VSS.t19 120.433
R108 VSS.t41 VSS.t0 120.433
R109 VSS.t28 VSS.t12 120.433
R110 VSS.t25 VSS.t2 120.433
R111 VSS.n40 VSS.t37 118.897
R112 VSS.n34 VSS.t11 118.897
R113 VSS.n25 VSS.t5 118.897
R114 VSS.n19 VSS.t46 118.897
R115 VSS.n40 VSS.n39 109.626
R116 VSS.n42 VSS.n41 109.626
R117 VSS.n44 VSS.n43 109.626
R118 VSS.n46 VSS.n45 109.626
R119 VSS.n38 VSS.n37 109.626
R120 VSS.n36 VSS.n35 109.626
R121 VSS.n34 VSS.n33 109.626
R122 VSS.n25 VSS.n24 109.626
R123 VSS.n27 VSS.n26 109.626
R124 VSS.n29 VSS.n28 109.626
R125 VSS.n31 VSS.n30 109.626
R126 VSS.n23 VSS.n22 109.626
R127 VSS.n21 VSS.n20 109.626
R128 VSS.n19 VSS.n18 109.626
R129 VSS.n6 VSS.t10 60.2169
R130 VSS.n6 VSS.t32 60.2169
R131 VSS.n8 VSS.t6 60.2169
R132 VSS.t14 VSS.n8 60.2169
R133 VSS.n9 VSS.t34 60.2169
R134 VSS.t16 VSS.n9 60.2169
R135 VSS.n16 VSS.t8 60.2169
R136 VSS.n16 VSS.t21 60.2169
R137 VSS.t19 VSS.n15 60.2169
R138 VSS.n15 VSS.t41 60.2169
R139 VSS.t0 VSS.n14 60.2169
R140 VSS.n14 VSS.t12 60.2169
R141 VSS.n11 VSS.t28 60.2169
R142 VSS.n11 VSS.t25 60.2169
R143 VSS.t2 VSS.n10 60.2169
R144 VSS.n10 VSS.t4 60.2169
R145 VSS.n39 VSS.t26 8.88939
R146 VSS.n39 VSS.t31 8.88939
R147 VSS.n41 VSS.t36 8.88939
R148 VSS.n41 VSS.t39 8.88939
R149 VSS.n43 VSS.t42 8.88939
R150 VSS.n43 VSS.t24 8.88939
R151 VSS.n45 VSS.t30 8.88939
R152 VSS.n45 VSS.t20 8.88939
R153 VSS.n37 VSS.t17 8.88939
R154 VSS.n37 VSS.t18 8.88939
R155 VSS.n35 VSS.t23 8.88939
R156 VSS.n35 VSS.t35 8.88939
R157 VSS.n33 VSS.t33 8.88939
R158 VSS.n33 VSS.t40 8.88939
R159 VSS.n24 VSS.t44 8.88939
R160 VSS.n24 VSS.t3 8.88939
R161 VSS.n26 VSS.t13 8.88939
R162 VSS.n26 VSS.t29 8.88939
R163 VSS.n28 VSS.t43 8.88939
R164 VSS.n28 VSS.t1 8.88939
R165 VSS.n30 VSS.t22 8.88939
R166 VSS.n30 VSS.t27 8.88939
R167 VSS.n22 VSS.t47 8.88939
R168 VSS.n22 VSS.t9 8.88939
R169 VSS.n20 VSS.t15 8.88939
R170 VSS.n20 VSS.t38 8.88939
R171 VSS.n18 VSS.t45 8.88939
R172 VSS.n18 VSS.t7 8.88939
R173 VSS.n48 VSS.n32 7.1255
R174 VSS.n49 VSS.n17 6.188
R175 VSS.n4 VSS 4.75607
R176 VSS.n48 VSS.n47 4.5005
R177 VSS.n50 VSS.n49 3.82821
R178 VSS VSS.n50 3.58615
R179 VSS.n49 VSS.n48 0.7505
R180 VSS.n36 VSS.n34 0.384429
R181 VSS.n38 VSS.n36 0.384429
R182 VSS.n46 VSS.n44 0.384429
R183 VSS.n44 VSS.n42 0.384429
R184 VSS.n42 VSS.n40 0.384429
R185 VSS.n21 VSS.n19 0.384429
R186 VSS.n23 VSS.n21 0.384429
R187 VSS.n31 VSS.n29 0.384429
R188 VSS.n29 VSS.n27 0.384429
R189 VSS.n27 VSS.n25 0.384429
R190 VSS.n7 VSS.n1 0.384429
R191 VSS.n17 VSS.n1 0.384429
R192 VSS.n17 VSS.n2 0.384429
R193 VSS.n13 VSS.n2 0.384429
R194 VSS.n13 VSS.n12 0.384429
R195 VSS.n50 VSS.n0 0.290138
R196 VSS.n4 VSS.n0 0.253603
R197 VSS.n47 VSS.n38 0.192464
R198 VSS.n47 VSS.n46 0.192464
R199 VSS.n32 VSS.n23 0.192464
R200 VSS.n32 VSS.n31 0.192464
R201 m1_4128_1316.n9 m1_4128_1316.n7 132.281
R202 m1_4128_1316.n6 m1_4128_1316.n4 132.28
R203 m1_4128_1316.n3 m1_4128_1316.n1 131.513
R204 m1_4128_1316.n12 m1_4128_1316.n0 131.513
R205 m1_4128_1316.n3 m1_4128_1316.n2 131.13
R206 m1_4128_1316.n9 m1_4128_1316.n8 131.13
R207 m1_4128_1316.n6 m1_4128_1316.n5 131.13
R208 m1_4128_1316.n13 m1_4128_1316.n12 131.127
R209 m1_4128_1316.n11 m1_4128_1316.n10 11.6255
R210 m1_4128_1316.n1 m1_4128_1316.t6 8.88939
R211 m1_4128_1316.n1 m1_4128_1316.t14 8.88939
R212 m1_4128_1316.n2 m1_4128_1316.t0 8.88939
R213 m1_4128_1316.n2 m1_4128_1316.t3 8.88939
R214 m1_4128_1316.n0 m1_4128_1316.t1 8.88939
R215 m1_4128_1316.n0 m1_4128_1316.t4 8.88939
R216 m1_4128_1316.n7 m1_4128_1316.t8 8.88939
R217 m1_4128_1316.n7 m1_4128_1316.t11 8.88939
R218 m1_4128_1316.n8 m1_4128_1316.t10 8.88939
R219 m1_4128_1316.n8 m1_4128_1316.t13 8.88939
R220 m1_4128_1316.n5 m1_4128_1316.t5 8.88939
R221 m1_4128_1316.n5 m1_4128_1316.t7 8.88939
R222 m1_4128_1316.n4 m1_4128_1316.t2 8.88939
R223 m1_4128_1316.n4 m1_4128_1316.t9 8.88939
R224 m1_4128_1316.n13 m1_4128_1316.t12 8.88939
R225 m1_4128_1316.t15 m1_4128_1316.n13 8.88939
R226 m1_4128_1316.n12 m1_4128_1316.n11 0.576393
R227 m1_4128_1316.n11 m1_4128_1316.n3 0.576393
R228 m1_4128_1316.n10 m1_4128_1316.n6 0.192464
R229 m1_4128_1316.n10 m1_4128_1316.n9 0.192464
R230 VCP.n26 VCP.t13 568.582
R231 VCP.n26 VCP.t12 568.582
R232 VCP.n27 VCP.t4 568.582
R233 VCP.n27 VCP.t0 568.582
R234 VCP.n29 VCP.t14 568.582
R235 VCP.n29 VCP.t9 568.582
R236 VCP.n31 VCP.t5 568.582
R237 VCP.n31 VCP.t1 568.582
R238 VCP.n25 VCP.t10 568.582
R239 VCP.n25 VCP.t6 568.582
R240 VCP.n23 VCP.t2 568.582
R241 VCP.n23 VCP.t15 568.582
R242 VCP.n21 VCP.t11 568.582
R243 VCP.n21 VCP.t7 568.582
R244 VCP.n19 VCP.t17 568.582
R245 VCP.n19 VCP.t16 568.582
R246 VCP.n17 VCP.t8 568.582
R247 VCP.n17 VCP.t3 568.582
R248 VCP.n15 VCP.t21 568.582
R249 VCP.n15 VCP.t26 568.582
R250 VCP.n13 VCP.t34 568.582
R251 VCP.n13 VCP.t35 568.582
R252 VCP.n11 VCP.t25 568.582
R253 VCP.n11 VCP.t29 568.582
R254 VCP.n9 VCP.t33 568.582
R255 VCP.n9 VCP.t20 568.582
R256 VCP.n7 VCP.t24 568.582
R257 VCP.n7 VCP.t28 568.582
R258 VCP.n5 VCP.t19 568.582
R259 VCP.n5 VCP.t23 568.582
R260 VCP.n3 VCP.t27 568.582
R261 VCP.n3 VCP.t32 568.582
R262 VCP.n1 VCP.t18 568.582
R263 VCP.n1 VCP.t22 568.582
R264 VCP.n0 VCP.t30 568.582
R265 VCP.n0 VCP.t31 568.582
R266 VCP.n28 VCP.n26 161.685
R267 VCP.n2 VCP.n0 161.685
R268 VCP.n28 VCP.n27 161.3
R269 VCP.n30 VCP.n29 161.3
R270 VCP.n32 VCP.n31 161.3
R271 VCP VCP.n25 161.3
R272 VCP.n24 VCP.n23 161.3
R273 VCP.n22 VCP.n21 161.3
R274 VCP.n20 VCP.n19 161.3
R275 VCP.n18 VCP.n17 161.3
R276 VCP.n16 VCP.n15 161.3
R277 VCP.n14 VCP.n13 161.3
R278 VCP.n12 VCP.n11 161.3
R279 VCP.n10 VCP.n9 161.3
R280 VCP.n8 VCP.n7 161.3
R281 VCP.n6 VCP.n5 161.3
R282 VCP.n4 VCP.n3 161.3
R283 VCP.n2 VCP.n1 161.3
R284 VCP.n18 VCP.n16 84.4317
R285 VCP.n4 VCP.n2 0.384429
R286 VCP.n6 VCP.n4 0.384429
R287 VCP.n8 VCP.n6 0.384429
R288 VCP.n10 VCP.n8 0.384429
R289 VCP.n12 VCP.n10 0.384429
R290 VCP.n14 VCP.n12 0.384429
R291 VCP.n16 VCP.n14 0.384429
R292 VCP.n20 VCP.n18 0.384429
R293 VCP.n22 VCP.n20 0.384429
R294 VCP.n24 VCP.n22 0.384429
R295 VCP VCP.n24 0.384429
R296 VCP VCP.n32 0.384429
R297 VCP.n32 VCP.n30 0.384429
R298 VCP.n30 VCP.n28 0.384429
R299 VIN.n1 VIN.t0 568.582
R300 VIN.n1 VIN.t1 568.582
R301 VIN.n0 VIN.t2 568.582
R302 VIN.n0 VIN.t3 568.582
R303 VIN VIN.n1 161.493
R304 VIN VIN.n0 161.493
R305 VIP.n1 VIP.t3 568.582
R306 VIP.n1 VIP.t2 568.582
R307 VIP.n0 VIP.t1 568.582
R308 VIP.n0 VIP.t0 568.582
R309 VIP VIP.n1 161.493
R310 VIP VIP.n0 161.493
R311 VCN.n14 VCN.t7 568.582
R312 VCN.n14 VCN.t8 568.582
R313 VCN.n15 VCN.t0 568.582
R314 VCN.n15 VCN.t2 568.582
R315 VCN.n13 VCN.t5 568.582
R316 VCN.n13 VCN.t9 568.582
R317 VCN.n11 VCN.t1 568.582
R318 VCN.n11 VCN.t3 568.582
R319 VCN.n9 VCN.t4 568.582
R320 VCN.n9 VCN.t6 568.582
R321 VCN.n7 VCN.t16 568.582
R322 VCN.n7 VCN.t14 568.582
R323 VCN.n5 VCN.t13 568.582
R324 VCN.n5 VCN.t11 568.582
R325 VCN.n3 VCN.t19 568.582
R326 VCN.n3 VCN.t15 568.582
R327 VCN.n1 VCN.t12 568.582
R328 VCN.n1 VCN.t10 568.582
R329 VCN.n0 VCN.t18 568.582
R330 VCN.n0 VCN.t17 568.582
R331 VCN.n16 VCN.n14 161.685
R332 VCN.n2 VCN.n0 161.685
R333 VCN.n16 VCN.n15 161.3
R334 VCN VCN.n13 161.3
R335 VCN.n12 VCN.n11 161.3
R336 VCN.n10 VCN.n9 161.3
R337 VCN.n8 VCN.n7 161.3
R338 VCN.n6 VCN.n5 161.3
R339 VCN.n4 VCN.n3 161.3
R340 VCN.n2 VCN.n1 161.3
R341 VCN.n10 VCN.n8 1.15229
R342 VCN.n4 VCN.n2 0.384429
R343 VCN.n6 VCN.n4 0.384429
R344 VCN.n8 VCN.n6 0.384429
R345 VCN.n12 VCN.n10 0.384429
R346 VCN VCN.n12 0.384429
R347 VCN VCN.n16 0.384429
C0 VIP m1_4698_1400# 8.32e-19
C1 VCP VDD 0.741443f
C2 VCP IB 0.003705f
C3 VCN m1_4698_1400# -0.001786f
C4 m1_5902_1316# m1_4698_1400# 0.016677f
C5 m1_5730_1400# m1_4698_1400# 0.41452f
C6 m1_3838_1400# VCN -0.083726f
C7 m1_3838_1400# m1_5730_1400# 0.92763f
C8 VCN VOUT -3.67e-19
C9 VIN VIP 0.029285f
C10 m1_5730_1400# VOUT 0.178471f
C11 VIN VCN 0.00381f
C12 VIN m1_5730_1400# 1.43e-19
C13 m1_3838_1400# m1_4698_1400# 0.068523f
C14 VOUT m1_4698_1400# 2.28e-19
C15 VDD VIP 0.063494f
C16 m1_2462_1316# VCN 1.98e-19
C17 m1_2462_1316# m1_5730_1400# 0.001793f
C18 VDD VCN 0.061979f
C19 VDD m1_5902_1316# 0.460033f
C20 VDD m1_5730_1400# 0.866485f
C21 IB m1_5730_1400# 8.03e-19
C22 VDD m1_4698_1400# 0.171596f
C23 m1_3838_1400# VOUT 0.133105f
C24 m1_3838_1400# VIN 8.32e-19
C25 VCP VIP 0.245496f
C26 VIN VOUT 7.62e-19
C27 VCP VCN 0.003928f
C28 VCP m1_5902_1316# 0.013447f
C29 VCP m1_5730_1400# 0.03425f
C30 m1_3838_1400# m1_2462_1316# 0.016661f
C31 m1_3838_1400# VDD 0.069964f
C32 m1_2462_1316# VOUT 0.339411f
C33 VCP m1_4698_1400# 2.87e-19
C34 VDD VOUT 0.314931f
C35 IB VOUT 0.002266f
C36 VIN m1_2462_1316# 4.08e-19
C37 VIN VDD 0.039372f
C38 VDD m1_2462_1316# 0.446966f
C39 IB m1_2462_1316# 0.020352f
C40 IB VDD 0.412949f
C41 VCP m1_3838_1400# 2.87e-19
C42 VCP VOUT 0.006844f
C43 VIP VCN 0.00381f
C44 VIP m1_5902_1316# 4.08e-19
C45 VCP VIN 0.245496f
C46 VIP m1_5730_1400# 0.001072f
C47 m1_5902_1316# VCN 1.98e-19
C48 m1_5730_1400# VCN 0.278026f
C49 m1_5730_1400# m1_5902_1316# 0.487665f
C50 VCP m1_2462_1316# 0.013447f
C51 VOUT VSS 10.737226f
C52 VCN VSS 4.090823f
C53 VCP VSS 1.794703f
C54 VCP.t30 VSS 0.045931f
C55 VCP.t31 VSS 0.045931f
C56 VCP.n0 VSS 0.099631f
C57 VCP.t18 VSS 0.045931f
C58 VCP.t22 VSS 0.045931f
C59 VCP.n1 VSS 0.099389f
C60 VCP.n2 VSS 0.222191f
C61 VCP.t27 VSS 0.045931f
C62 VCP.t32 VSS 0.045931f
C63 VCP.n3 VSS 0.099389f
C64 VCP.n4 VSS 0.120368f
C65 VCP.t19 VSS 0.045931f
C66 VCP.t23 VSS 0.045931f
C67 VCP.n5 VSS 0.099389f
C68 VCP.n6 VSS 0.120368f
C69 VCP.t24 VSS 0.045931f
C70 VCP.t28 VSS 0.045931f
C71 VCP.n7 VSS 0.099389f
C72 VCP.n8 VSS 0.120368f
C73 VCP.t33 VSS 0.045931f
C74 VCP.t20 VSS 0.045931f
C75 VCP.n9 VSS 0.099389f
C76 VCP.n10 VSS 0.120368f
C77 VCP.t25 VSS 0.045931f
C78 VCP.t29 VSS 0.045931f
C79 VCP.n11 VSS 0.099389f
C80 VCP.n12 VSS 0.120368f
C81 VCP.t34 VSS 0.045931f
C82 VCP.t35 VSS 0.045931f
C83 VCP.n13 VSS 0.099389f
C84 VCP.n14 VSS 0.120368f
C85 VCP.t21 VSS 0.045931f
C86 VCP.t26 VSS 0.045931f
C87 VCP.n15 VSS 0.099389f
C88 VCP.n16 VSS 0.484108f
C89 VCP.t8 VSS 0.045931f
C90 VCP.t3 VSS 0.045931f
C91 VCP.n17 VSS 0.099389f
C92 VCP.n18 VSS 0.484108f
C93 VCP.t17 VSS 0.045931f
C94 VCP.t16 VSS 0.045931f
C95 VCP.n19 VSS 0.099389f
C96 VCP.n20 VSS 0.120368f
C97 VCP.t11 VSS 0.045931f
C98 VCP.t7 VSS 0.045931f
C99 VCP.n21 VSS 0.099389f
C100 VCP.n22 VSS 0.120368f
C101 VCP.t2 VSS 0.045931f
C102 VCP.t15 VSS 0.045931f
C103 VCP.n23 VSS 0.099389f
C104 VCP.n24 VSS 0.120368f
C105 VCP.t10 VSS 0.045931f
C106 VCP.t6 VSS 0.045931f
C107 VCP.n25 VSS 0.099389f
C108 VCP.t13 VSS 0.045931f
C109 VCP.t12 VSS 0.045931f
C110 VCP.n26 VSS 0.099631f
C111 VCP.t4 VSS 0.045931f
C112 VCP.t0 VSS 0.045931f
C113 VCP.n27 VSS 0.099389f
C114 VCP.n28 VSS 0.222191f
C115 VCP.t14 VSS 0.045931f
C116 VCP.t9 VSS 0.045931f
C117 VCP.n29 VSS 0.099389f
C118 VCP.n30 VSS 0.120368f
C119 VCP.t5 VSS 0.045931f
C120 VCP.t1 VSS 0.045931f
C121 VCP.n31 VSS 0.099389f
C122 VCP.n32 VSS 0.120368f
C123 m1_4128_1316.t12 VSS 0.010519f
C124 m1_4128_1316.t1 VSS 0.010519f
C125 m1_4128_1316.t4 VSS 0.010519f
C126 m1_4128_1316.n0 VSS 0.05384f
C127 m1_4128_1316.t6 VSS 0.010519f
C128 m1_4128_1316.t14 VSS 0.010519f
C129 m1_4128_1316.n1 VSS 0.05384f
C130 m1_4128_1316.t0 VSS 0.010519f
C131 m1_4128_1316.t3 VSS 0.010519f
C132 m1_4128_1316.n2 VSS 0.053691f
C133 m1_4128_1316.n3 VSS 0.112174f
C134 m1_4128_1316.t2 VSS 0.010519f
C135 m1_4128_1316.t9 VSS 0.010519f
C136 m1_4128_1316.n4 VSS 0.054301f
C137 m1_4128_1316.t5 VSS 0.010519f
C138 m1_4128_1316.t7 VSS 0.010519f
C139 m1_4128_1316.n5 VSS 0.053691f
C140 m1_4128_1316.n6 VSS 0.140432f
C141 m1_4128_1316.t8 VSS 0.010519f
C142 m1_4128_1316.t11 VSS 0.010519f
C143 m1_4128_1316.n7 VSS 0.054301f
C144 m1_4128_1316.t10 VSS 0.010519f
C145 m1_4128_1316.t13 VSS 0.010519f
C146 m1_4128_1316.n8 VSS 0.053691f
C147 m1_4128_1316.n9 VSS 0.140432f
C148 m1_4128_1316.n10 VSS 1.10451f
C149 m1_4128_1316.n11 VSS 0.790924f
C150 m1_4128_1316.n12 VSS 0.112174f
C151 m1_4128_1316.n13 VSS 0.053691f
C152 m1_4128_1316.t15 VSS 0.010519f
C153 IB.t45 VSS 0.014882f
C154 IB.t38 VSS 0.014882f
C155 IB.n0 VSS 0.032282f
C156 IB.t10 VSS 0.014882f
C157 IB.t20 VSS 0.014882f
C158 IB.n1 VSS 0.032204f
C159 IB.n2 VSS 0.071994f
C160 IB.t12 VSS 0.014882f
C161 IB.t28 VSS 0.014882f
C162 IB.n3 VSS 0.032204f
C163 IB.n4 VSS 0.039002f
C164 IB.t42 VSS 0.014882f
C165 IB.t40 VSS 0.014882f
C166 IB.n5 VSS 0.032204f
C167 IB.n6 VSS 0.039002f
C168 IB.t37 VSS 0.014882f
C169 IB.t34 VSS 0.014882f
C170 IB.n7 VSS 0.032204f
C171 IB.t39 VSS 0.014882f
C172 IB.t36 VSS 0.014882f
C173 IB.n8 VSS 0.032282f
C174 IB.t24 VSS 0.014882f
C175 IB.t16 VSS 0.014882f
C176 IB.n9 VSS 0.032204f
C177 IB.n10 VSS 0.071994f
C178 IB.t18 VSS 0.014882f
C179 IB.t8 VSS 0.014882f
C180 IB.n11 VSS 0.032204f
C181 IB.n12 VSS 0.039002f
C182 IB.n13 VSS 0.054164f
C183 IB.t11 VSS 0.010778f
C184 IB.t21 VSS 0.010778f
C185 IB.n14 VSS 0.0597f
C186 IB.t13 VSS 0.010778f
C187 IB.t29 VSS 0.010778f
C188 IB.n15 VSS 0.059581f
C189 IB.n16 VSS 0.110732f
C190 IB.t25 VSS 0.010778f
C191 IB.t17 VSS 0.010778f
C192 IB.n17 VSS 0.0597f
C193 IB.t19 VSS 0.010778f
C194 IB.t9 VSS 0.010778f
C195 IB.n18 VSS 0.059581f
C196 IB.n19 VSS 0.100924f
C197 IB.n20 VSS 0.029426f
C198 IB.n21 VSS 0.093873f
C199 IB.t31 VSS 0.010778f
C200 IB.t15 VSS 0.010778f
C201 IB.n22 VSS 0.060084f
C202 IB.t7 VSS 0.010778f
C203 IB.t23 VSS 0.010778f
C204 IB.n23 VSS 0.059581f
C205 IB.n24 VSS 0.139774f
C206 IB.t5 VSS 0.010778f
C207 IB.t3 VSS 0.010778f
C208 IB.n25 VSS 0.059581f
C209 IB.t1 VSS 0.010778f
C210 IB.t27 VSS 0.010778f
C211 IB.n26 VSS 0.060084f
C212 IB.n27 VSS 0.154937f
C213 IB.t30 VSS 0.014882f
C214 IB.t14 VSS 0.014882f
C215 IB.n28 VSS 0.032282f
C216 IB.t46 VSS 0.014882f
C217 IB.t43 VSS 0.014882f
C218 IB.n29 VSS 0.032204f
C219 IB.n30 VSS 0.071994f
C220 IB.t35 VSS 0.014882f
C221 IB.t32 VSS 0.014882f
C222 IB.n31 VSS 0.032204f
C223 IB.n32 VSS 0.039002f
C224 IB.t6 VSS 0.014882f
C225 IB.t22 VSS 0.014882f
C226 IB.n33 VSS 0.032204f
C227 IB.n34 VSS 0.039002f
C228 IB.t4 VSS 0.014882f
C229 IB.t2 VSS 0.014882f
C230 IB.n35 VSS 0.032204f
C231 IB.t0 VSS 0.014882f
C232 IB.t26 VSS 0.014882f
C233 IB.n36 VSS 0.032282f
C234 IB.t41 VSS 0.014882f
C235 IB.t33 VSS 0.014882f
C236 IB.n37 VSS 0.032204f
C237 IB.n38 VSS 0.071994f
C238 IB.t47 VSS 0.014882f
C239 IB.t44 VSS 0.014882f
C240 IB.n39 VSS 0.032204f
C241 IB.n40 VSS 0.039002f
C242 IB.n41 VSS 0.039002f
C243 IB.n42 VSS 0.093873f
C244 m1_5730_1400# VSS 2.032821f
C245 m1_4698_1400# VSS 0.825268f
C246 VIP VSS 0.772797f
C247 m1_5902_1316# VSS 0.31723f
C248 m1_3838_1400# VSS 0.944126f
C249 VIN VSS 0.821366f
C250 m1_2462_1316# VSS 0.368415f
C251 VDD VSS 55.47847f
C252 IB VSS 13.887003f
.ends
