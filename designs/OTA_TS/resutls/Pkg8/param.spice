.param VDD=1.71 VCM=0.89 VCP=0.56 VCN=1.19 IB=26u vi=0.04 fi=100000 L1=0.15 L3=0.15 L5=0.15 L7=0.15 LT=0.15 LB=0.15 W1=18.9 W3=34.02 W5=18.9 W7=7.56 WT=30.24 WB=30.24 NF1=10 NF3=18 NF5=10 NF7=4 NFT=16 NFB=16
