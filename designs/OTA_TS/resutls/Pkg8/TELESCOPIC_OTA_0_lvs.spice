* NGSPICE file created from TELESCOPIC_OTA_0.ext - technology: sky130A

.subckt SCM_NMOS_21822889_X4_Y2_1774869491 a_230_1554# a_200_252# a_147_378#
X0 a_230_1554# a_200_252# a_147_378# a_147_378# sky130_fd_pr__nfet_01v8 ad=0.2646 pd=2.17 as=0.2646 ps=2.17 w=1.89 l=0.15 M=16
X1 a_147_378# a_200_252# a_200_252# a_147_378# sky130_fd_pr__nfet_01v8 ad=0.50085 pd=4.31 as=0.2646 ps=2.17 w=1.89 l=0.15 M=16
.ends

.subckt PMOS_4T_59417588_X9_Y1_1774869489 a_200_252# a_230_378# w_0_0# a_147_378#
X0 a_230_378# a_200_252# a_147_378# w_0_0# sky130_fd_pr__pfet_01v8 ad=0.2646 pd=2.17 as=0.2646 ps=2.17 w=1.89 l=0.15 M=18
.ends

.subckt NMOS_4T_74585927_X2_Y1_1774869487 a_200_252# a_230_378# a_147_378# a_241_1232#
X0 a_230_378# a_200_252# a_147_378# a_241_1232# sky130_fd_pr__nfet_01v8 ad=0.2646 pd=2.17 as=0.2646 ps=2.17 w=1.89 l=0.15 M=4
.ends

.subckt NMOS_4T_96640015_X5_Y1_1774869488 a_200_252# a_230_378# a_147_378# a_241_1232#
X0 a_230_378# a_200_252# a_147_378# a_241_1232# sky130_fd_pr__nfet_01v8 ad=0.2646 pd=2.17 as=0.2646 ps=2.17 w=1.89 l=0.15 M=10
.ends

.subckt PMOS_S_72158034_X5_Y1_1774869490 a_200_252# a_230_378# w_0_0#
X0 a_230_378# a_200_252# w_0_0# w_0_0# sky130_fd_pr__pfet_01v8 ad=0.2646 pd=2.17 as=0.2646 ps=2.17 w=1.89 l=0.15 M=10
.ends

.subckt TELESCOPIC_OTA_0 IB VCN VOUT VIP VIN VCP VSS VDD
XSCM_NMOS_21822889_X4_Y2_1774869491_0 m1_4128_1316# IB VSS SCM_NMOS_21822889_X4_Y2_1774869491
XPMOS_4T_59417588_X9_Y1_1774869489_0 VCP VOUT VDD m1_2462_1316# PMOS_4T_59417588_X9_Y1_1774869489
XNMOS_4T_74585927_X2_Y1_1774869487_0 VIN m1_3838_1400# m1_4128_1316# VSS NMOS_4T_74585927_X2_Y1_1774869487
XPMOS_4T_59417588_X9_Y1_1774869489_1 VCP m1_5730_1400# VDD m1_5902_1316# PMOS_4T_59417588_X9_Y1_1774869489
XNMOS_4T_74585927_X2_Y1_1774869487_1 VIP m1_4698_1400# m1_4128_1316# VSS NMOS_4T_74585927_X2_Y1_1774869487
XNMOS_4T_96640015_X5_Y1_1774869488_0 VCN VOUT m1_3838_1400# VSS NMOS_4T_96640015_X5_Y1_1774869488
XNMOS_4T_96640015_X5_Y1_1774869488_1 VCN m1_5730_1400# m1_4698_1400# VSS NMOS_4T_96640015_X5_Y1_1774869488
XPMOS_S_72158034_X5_Y1_1774869490_1 m1_5730_1400# m1_5902_1316# VDD PMOS_S_72158034_X5_Y1_1774869490
XPMOS_S_72158034_X5_Y1_1774869490_0 m1_5730_1400# m1_2462_1316# VDD PMOS_S_72158034_X5_Y1_1774869490
.ends
