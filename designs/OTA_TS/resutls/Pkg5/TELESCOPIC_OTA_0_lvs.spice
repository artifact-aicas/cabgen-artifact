* NGSPICE file created from TELESCOPIC_OTA_0.ext - technology: sky130A

.subckt PMOS_S_77937488_X8_Y1_1774869395 a_230_441# a_200_252# w_0_0#
X0 w_0_0# a_200_252# a_230_441# w_0_0# sky130_fd_pr__pfet_01v8 ad=0.1764 pd=1.54 as=0.1764 ps=1.54 w=1.26 l=0.15 M=16
.ends

.subckt PMOS_4T_36899923_X2_Y1_1774869394 a_230_441# a_200_252# a_147_441# w_0_0#
X0 a_147_441# a_200_252# a_230_441# w_0_0# sky130_fd_pr__pfet_01v8 ad=0.1764 pd=1.54 as=0.1764 ps=1.54 w=1.26 l=0.15 M=4
.ends

.subckt NMOS_4T_27824333_X5_Y1_1774869392 a_230_441# a_200_252# a_147_441# a_241_1232#
X0 a_147_441# a_200_252# a_230_441# a_241_1232# sky130_fd_pr__nfet_01v8 ad=0.3339 pd=3.05 as=0.1764 ps=1.54 w=1.26 l=0.15 M=10
.ends

.subckt NMOS_4T_50719370_X4_Y1_1774869393 a_230_441# a_200_252# a_147_441# a_241_1232#
X0 a_230_441# a_200_252# a_147_441# a_241_1232# sky130_fd_pr__nfet_01v8 ad=0.1764 pd=1.54 as=0.3339 ps=3.05 w=1.26 l=0.15 M=8
.ends

.subckt SCM_NMOS_14227459_X10_Y1_1774869396 a_402_441# a_200_252# a_147_441#
X0 a_147_441# a_200_252# a_200_252# a_147_441# sky130_fd_pr__nfet_01v8 ad=0.1764 pd=1.54 as=0.1764 ps=1.54 w=1.26 l=0.15 M=20
X1 a_147_441# a_200_252# a_402_441# a_147_441# sky130_fd_pr__nfet_01v8 ad=0.1764 pd=1.54 as=0.1764 ps=1.54 w=1.26 l=0.15 M=20
.ends

.subckt TELESCOPIC_OTA_0 IB VCN VOUT VIP VIN VCP VSS VDD
XPMOS_S_77937488_X8_Y1_1774869395_0 li_3071_3091# m1_3150_2912# VDD PMOS_S_77937488_X8_Y1_1774869395
XPMOS_S_77937488_X8_Y1_1774869395_1 li_1695_3091# m1_3150_2912# VDD PMOS_S_77937488_X8_Y1_1774869395
XPMOS_4T_36899923_X2_Y1_1774869394_0 VOUT VCP li_3071_3091# VDD PMOS_4T_36899923_X2_Y1_1774869394
XPMOS_4T_36899923_X2_Y1_1774869394_1 m1_3150_2912# VCP li_1695_3091# VDD PMOS_4T_36899923_X2_Y1_1774869394
XNMOS_4T_27824333_X5_Y1_1774869392_0 li_1351_2839# VIN m1_3354_1316# VSS NMOS_4T_27824333_X5_Y1_1774869392
XNMOS_4T_27824333_X5_Y1_1774869392_1 li_3415_2755# VIP m1_3354_1316# VSS NMOS_4T_27824333_X5_Y1_1774869392
XNMOS_4T_50719370_X4_Y1_1774869393_0 VOUT VCN li_1351_2839# VSS NMOS_4T_50719370_X4_Y1_1774869393
XNMOS_4T_50719370_X4_Y1_1774869393_1 m1_3150_2912# VCN li_3415_2755# VSS NMOS_4T_50719370_X4_Y1_1774869393
XSCM_NMOS_14227459_X10_Y1_1774869396_0 m1_3354_1316# IB VSS SCM_NMOS_14227459_X10_Y1_1774869396
.ends
