* NGSPICE file created from TELESCOPIC_OTA_0.ext - technology: sky130A

.subckt PMOS_S_77937488_X8_Y1_1774869395 a_230_441# a_200_252# w_0_0# VSUBS
X0 w_0_0# a_200_252# a_230_441# w_0_0# sky130_fd_pr__pfet_01v8 ad=0.1764 pd=1.54 as=0.1764 ps=1.54 w=1.26 l=0.15
X1 w_0_0# a_200_252# a_230_441# w_0_0# sky130_fd_pr__pfet_01v8 ad=0.1764 pd=1.54 as=0.1764 ps=1.54 w=1.26 l=0.15
X2 a_230_441# a_200_252# w_0_0# w_0_0# sky130_fd_pr__pfet_01v8 ad=0.1764 pd=1.54 as=0.1764 ps=1.54 w=1.26 l=0.15
X3 w_0_0# a_200_252# a_230_441# w_0_0# sky130_fd_pr__pfet_01v8 ad=0.3339 pd=3.05 as=0.1764 ps=1.54 w=1.26 l=0.15
X4 a_230_441# a_200_252# w_0_0# w_0_0# sky130_fd_pr__pfet_01v8 ad=0.1764 pd=1.54 as=0.1764 ps=1.54 w=1.26 l=0.15
X5 a_230_441# a_200_252# w_0_0# w_0_0# sky130_fd_pr__pfet_01v8 ad=0.1764 pd=1.54 as=0.1764 ps=1.54 w=1.26 l=0.15
X6 a_230_441# a_200_252# w_0_0# w_0_0# sky130_fd_pr__pfet_01v8 ad=0.1764 pd=1.54 as=0.1764 ps=1.54 w=1.26 l=0.15
X7 w_0_0# a_200_252# a_230_441# w_0_0# sky130_fd_pr__pfet_01v8 ad=0.1764 pd=1.54 as=0.1764 ps=1.54 w=1.26 l=0.15
X8 w_0_0# a_200_252# a_230_441# w_0_0# sky130_fd_pr__pfet_01v8 ad=0.1764 pd=1.54 as=0.1764 ps=1.54 w=1.26 l=0.15
X9 w_0_0# a_200_252# a_230_441# w_0_0# sky130_fd_pr__pfet_01v8 ad=0.1764 pd=1.54 as=0.1764 ps=1.54 w=1.26 l=0.15
X10 a_230_441# a_200_252# w_0_0# w_0_0# sky130_fd_pr__pfet_01v8 ad=0.1764 pd=1.54 as=0.1764 ps=1.54 w=1.26 l=0.15
X11 a_230_441# a_200_252# w_0_0# w_0_0# sky130_fd_pr__pfet_01v8 ad=0.1764 pd=1.54 as=0.1764 ps=1.54 w=1.26 l=0.15
X12 a_230_441# a_200_252# w_0_0# w_0_0# sky130_fd_pr__pfet_01v8 ad=0.1764 pd=1.54 as=0.1764 ps=1.54 w=1.26 l=0.15
X13 w_0_0# a_200_252# a_230_441# w_0_0# sky130_fd_pr__pfet_01v8 ad=0.1764 pd=1.54 as=0.1764 ps=1.54 w=1.26 l=0.15
X14 w_0_0# a_200_252# a_230_441# w_0_0# sky130_fd_pr__pfet_01v8 ad=0.1764 pd=1.54 as=0.1764 ps=1.54 w=1.26 l=0.15
X15 a_230_441# a_200_252# w_0_0# w_0_0# sky130_fd_pr__pfet_01v8 ad=0.1764 pd=1.54 as=0.3339 ps=3.05 w=1.26 l=0.15
C0 w_0_0# a_230_441# 5.96746f
C1 a_200_252# a_230_441# 0.718508f
C2 a_200_252# w_0_0# 3.9098f
C3 a_230_441# VSUBS 0.326991f
C4 a_200_252# VSUBS 0.460324f
C5 w_0_0# VSUBS 8.10299f
.ends

.subckt PMOS_4T_36899923_X2_Y1_1774869394 a_230_441# a_200_252# a_147_441# w_0_0#
+ VSUBS
X0 a_147_441# a_200_252# a_230_441# w_0_0# sky130_fd_pr__pfet_01v8 ad=0.1764 pd=1.54 as=0.1764 ps=1.54 w=1.26 l=0.15
X1 a_230_441# a_200_252# a_147_441# w_0_0# sky130_fd_pr__pfet_01v8 ad=0.1764 pd=1.54 as=0.1764 ps=1.54 w=1.26 l=0.15
X2 a_147_441# a_200_252# a_230_441# w_0_0# sky130_fd_pr__pfet_01v8 ad=0.3339 pd=3.05 as=0.1764 ps=1.54 w=1.26 l=0.15
X3 a_230_441# a_200_252# a_147_441# w_0_0# sky130_fd_pr__pfet_01v8 ad=0.1764 pd=1.54 as=0.3339 ps=3.05 w=1.26 l=0.15
C0 a_230_441# a_147_441# 1.3461f
C1 w_0_0# a_147_441# 0.229025f
C2 w_0_0# a_230_441# 0.076817f
C3 a_200_252# a_147_441# 0.171288f
C4 a_200_252# a_230_441# 0.17932f
C5 a_200_252# w_0_0# 0.827115f
C6 a_230_441# VSUBS 0.078728f
C7 a_147_441# VSUBS 0.273523f
C8 a_200_252# VSUBS 0.212118f
C9 w_0_0# VSUBS 3.22536f
.ends

.subckt NMOS_4T_27824333_X5_Y1_1774869392 a_230_441# a_200_252# a_147_441# a_241_1232#
X0 a_147_441# a_200_252# a_230_441# a_241_1232# sky130_fd_pr__nfet_01v8 ad=0.3339 pd=3.05 as=0.1764 ps=1.54 w=1.26 l=0.15
X1 a_230_441# a_200_252# a_147_441# a_241_1232# sky130_fd_pr__nfet_01v8 ad=0.1764 pd=1.54 as=0.3339 ps=3.05 w=1.26 l=0.15
X2 a_147_441# a_200_252# a_230_441# a_241_1232# sky130_fd_pr__nfet_01v8 ad=0.1764 pd=1.54 as=0.1764 ps=1.54 w=1.26 l=0.15
X3 a_147_441# a_200_252# a_230_441# a_241_1232# sky130_fd_pr__nfet_01v8 ad=0.1764 pd=1.54 as=0.1764 ps=1.54 w=1.26 l=0.15
X4 a_230_441# a_200_252# a_147_441# a_241_1232# sky130_fd_pr__nfet_01v8 ad=0.1764 pd=1.54 as=0.1764 ps=1.54 w=1.26 l=0.15
X5 a_230_441# a_200_252# a_147_441# a_241_1232# sky130_fd_pr__nfet_01v8 ad=0.1764 pd=1.54 as=0.1764 ps=1.54 w=1.26 l=0.15
X6 a_147_441# a_200_252# a_230_441# a_241_1232# sky130_fd_pr__nfet_01v8 ad=0.1764 pd=1.54 as=0.1764 ps=1.54 w=1.26 l=0.15
X7 a_147_441# a_200_252# a_230_441# a_241_1232# sky130_fd_pr__nfet_01v8 ad=0.1764 pd=1.54 as=0.1764 ps=1.54 w=1.26 l=0.15
X8 a_230_441# a_200_252# a_147_441# a_241_1232# sky130_fd_pr__nfet_01v8 ad=0.1764 pd=1.54 as=0.1764 ps=1.54 w=1.26 l=0.15
X9 a_230_441# a_200_252# a_147_441# a_241_1232# sky130_fd_pr__nfet_01v8 ad=0.1764 pd=1.54 as=0.1764 ps=1.54 w=1.26 l=0.15
C0 a_200_252# a_230_441# 0.448914f
C1 a_147_441# a_230_441# 3.46199f
C2 a_147_441# a_200_252# 0.446006f
C3 a_230_441# a_241_1232# 0.392843f
C4 a_147_441# a_241_1232# 0.662662f
C5 a_200_252# a_241_1232# 2.26535f
.ends

.subckt NMOS_4T_50719370_X4_Y1_1774869393 a_230_441# a_200_252# a_147_441# a_241_1232#
X0 a_230_441# a_200_252# a_147_441# a_241_1232# sky130_fd_pr__nfet_01v8 ad=0.1764 pd=1.54 as=0.3339 ps=3.05 w=1.26 l=0.15
X1 a_147_441# a_200_252# a_230_441# a_241_1232# sky130_fd_pr__nfet_01v8 ad=0.1764 pd=1.54 as=0.1764 ps=1.54 w=1.26 l=0.15
X2 a_147_441# a_200_252# a_230_441# a_241_1232# sky130_fd_pr__nfet_01v8 ad=0.1764 pd=1.54 as=0.1764 ps=1.54 w=1.26 l=0.15
X3 a_230_441# a_200_252# a_147_441# a_241_1232# sky130_fd_pr__nfet_01v8 ad=0.1764 pd=1.54 as=0.1764 ps=1.54 w=1.26 l=0.15
X4 a_230_441# a_200_252# a_147_441# a_241_1232# sky130_fd_pr__nfet_01v8 ad=0.1764 pd=1.54 as=0.1764 ps=1.54 w=1.26 l=0.15
X5 a_147_441# a_200_252# a_230_441# a_241_1232# sky130_fd_pr__nfet_01v8 ad=0.1764 pd=1.54 as=0.1764 ps=1.54 w=1.26 l=0.15
X6 a_147_441# a_200_252# a_230_441# a_241_1232# sky130_fd_pr__nfet_01v8 ad=0.3339 pd=3.05 as=0.1764 ps=1.54 w=1.26 l=0.15
X7 a_230_441# a_200_252# a_147_441# a_241_1232# sky130_fd_pr__nfet_01v8 ad=0.1764 pd=1.54 as=0.1764 ps=1.54 w=1.26 l=0.15
C0 a_200_252# a_230_441# 0.359049f
C1 a_147_441# a_230_441# 2.75669f
C2 a_147_441# a_200_252# 0.354433f
C3 a_230_441# a_241_1232# 0.313744f
C4 a_147_441# a_241_1232# 0.609291f
C5 a_200_252# a_241_1232# 1.85664f
.ends

.subckt SCM_NMOS_14227459_X10_Y1_1774869396 a_402_441# a_200_252# a_147_441#
X0 a_147_441# a_200_252# a_200_252# a_147_441# sky130_fd_pr__nfet_01v8 ad=0.1764 pd=1.54 as=0.1764 ps=1.54 w=1.26 l=0.15
X1 a_200_252# a_200_252# a_147_441# a_147_441# sky130_fd_pr__nfet_01v8 ad=0.1764 pd=1.54 as=0.1764 ps=1.54 w=1.26 l=0.15
X2 a_147_441# a_200_252# a_200_252# a_147_441# sky130_fd_pr__nfet_01v8 ad=0.1764 pd=1.54 as=0.1764 ps=1.54 w=1.26 l=0.15
X3 a_200_252# a_200_252# a_147_441# a_147_441# sky130_fd_pr__nfet_01v8 ad=0.1764 pd=1.54 as=0.1764 ps=1.54 w=1.26 l=0.15
X4 a_147_441# a_200_252# a_402_441# a_147_441# sky130_fd_pr__nfet_01v8 ad=0.1764 pd=1.54 as=0.1764 ps=1.54 w=1.26 l=0.15
X5 a_200_252# a_200_252# a_147_441# a_147_441# sky130_fd_pr__nfet_01v8 ad=0.1764 pd=1.54 as=0.3339 ps=3.05 w=1.26 l=0.15
X6 a_402_441# a_200_252# a_147_441# a_147_441# sky130_fd_pr__nfet_01v8 ad=0.1764 pd=1.54 as=0.1764 ps=1.54 w=1.26 l=0.15
X7 a_147_441# a_200_252# a_200_252# a_147_441# sky130_fd_pr__nfet_01v8 ad=0.1764 pd=1.54 as=0.1764 ps=1.54 w=1.26 l=0.15
X8 a_200_252# a_200_252# a_147_441# a_147_441# sky130_fd_pr__nfet_01v8 ad=0.1764 pd=1.54 as=0.1764 ps=1.54 w=1.26 l=0.15
X9 a_147_441# a_200_252# a_402_441# a_147_441# sky130_fd_pr__nfet_01v8 ad=0.1764 pd=1.54 as=0.1764 ps=1.54 w=1.26 l=0.15
X10 a_402_441# a_200_252# a_147_441# a_147_441# sky130_fd_pr__nfet_01v8 ad=0.1764 pd=1.54 as=0.1764 ps=1.54 w=1.26 l=0.15
X11 a_147_441# a_200_252# a_402_441# a_147_441# sky130_fd_pr__nfet_01v8 ad=0.1764 pd=1.54 as=0.1764 ps=1.54 w=1.26 l=0.15
X12 a_402_441# a_200_252# a_147_441# a_147_441# sky130_fd_pr__nfet_01v8 ad=0.1764 pd=1.54 as=0.1764 ps=1.54 w=1.26 l=0.15
X13 a_402_441# a_200_252# a_147_441# a_147_441# sky130_fd_pr__nfet_01v8 ad=0.1764 pd=1.54 as=0.1764 ps=1.54 w=1.26 l=0.15
X14 a_147_441# a_200_252# a_200_252# a_147_441# sky130_fd_pr__nfet_01v8 ad=0.3339 pd=3.05 as=0.1764 ps=1.54 w=1.26 l=0.15
X15 a_200_252# a_200_252# a_147_441# a_147_441# sky130_fd_pr__nfet_01v8 ad=0.1764 pd=1.54 as=0.1764 ps=1.54 w=1.26 l=0.15
X16 a_147_441# a_200_252# a_200_252# a_147_441# sky130_fd_pr__nfet_01v8 ad=0.1764 pd=1.54 as=0.1764 ps=1.54 w=1.26 l=0.15
X17 a_147_441# a_200_252# a_402_441# a_147_441# sky130_fd_pr__nfet_01v8 ad=0.1764 pd=1.54 as=0.1764 ps=1.54 w=1.26 l=0.15
X18 a_402_441# a_200_252# a_147_441# a_147_441# sky130_fd_pr__nfet_01v8 ad=0.1764 pd=1.54 as=0.1764 ps=1.54 w=1.26 l=0.15
X19 a_147_441# a_200_252# a_200_252# a_147_441# sky130_fd_pr__nfet_01v8 ad=0.1764 pd=1.54 as=0.1764 ps=1.54 w=1.26 l=0.15
X20 a_200_252# a_200_252# a_147_441# a_147_441# sky130_fd_pr__nfet_01v8 ad=0.1764 pd=1.54 as=0.1764 ps=1.54 w=1.26 l=0.15
X21 a_200_252# a_200_252# a_147_441# a_147_441# sky130_fd_pr__nfet_01v8 ad=0.1764 pd=1.54 as=0.1764 ps=1.54 w=1.26 l=0.15
X22 a_147_441# a_200_252# a_402_441# a_147_441# sky130_fd_pr__nfet_01v8 ad=0.1764 pd=1.54 as=0.1764 ps=1.54 w=1.26 l=0.15
X23 a_402_441# a_200_252# a_147_441# a_147_441# sky130_fd_pr__nfet_01v8 ad=0.1764 pd=1.54 as=0.1764 ps=1.54 w=1.26 l=0.15
X24 a_147_441# a_200_252# a_402_441# a_147_441# sky130_fd_pr__nfet_01v8 ad=0.1764 pd=1.54 as=0.1764 ps=1.54 w=1.26 l=0.15
X25 a_200_252# a_200_252# a_147_441# a_147_441# sky130_fd_pr__nfet_01v8 ad=0.1764 pd=1.54 as=0.1764 ps=1.54 w=1.26 l=0.15
X26 a_402_441# a_200_252# a_147_441# a_147_441# sky130_fd_pr__nfet_01v8 ad=0.1764 pd=1.54 as=0.1764 ps=1.54 w=1.26 l=0.15
X27 a_147_441# a_200_252# a_402_441# a_147_441# sky130_fd_pr__nfet_01v8 ad=0.1764 pd=1.54 as=0.1764 ps=1.54 w=1.26 l=0.15
X28 a_200_252# a_200_252# a_147_441# a_147_441# sky130_fd_pr__nfet_01v8 ad=0.1764 pd=1.54 as=0.1764 ps=1.54 w=1.26 l=0.15
X29 a_147_441# a_200_252# a_402_441# a_147_441# sky130_fd_pr__nfet_01v8 ad=0.1764 pd=1.54 as=0.1764 ps=1.54 w=1.26 l=0.15
X30 a_147_441# a_200_252# a_200_252# a_147_441# sky130_fd_pr__nfet_01v8 ad=0.1764 pd=1.54 as=0.1764 ps=1.54 w=1.26 l=0.15
X31 a_402_441# a_200_252# a_147_441# a_147_441# sky130_fd_pr__nfet_01v8 ad=0.1764 pd=1.54 as=0.1764 ps=1.54 w=1.26 l=0.15
X32 a_200_252# a_200_252# a_147_441# a_147_441# sky130_fd_pr__nfet_01v8 ad=0.1764 pd=1.54 as=0.1764 ps=1.54 w=1.26 l=0.15
X33 a_147_441# a_200_252# a_200_252# a_147_441# sky130_fd_pr__nfet_01v8 ad=0.1764 pd=1.54 as=0.1764 ps=1.54 w=1.26 l=0.15
X34 a_147_441# a_200_252# a_402_441# a_147_441# sky130_fd_pr__nfet_01v8 ad=0.1764 pd=1.54 as=0.1764 ps=1.54 w=1.26 l=0.15
X35 a_402_441# a_200_252# a_147_441# a_147_441# sky130_fd_pr__nfet_01v8 ad=0.1764 pd=1.54 as=0.1764 ps=1.54 w=1.26 l=0.15
X36 a_147_441# a_200_252# a_200_252# a_147_441# sky130_fd_pr__nfet_01v8 ad=0.1764 pd=1.54 as=0.1764 ps=1.54 w=1.26 l=0.15
X37 a_402_441# a_200_252# a_147_441# a_147_441# sky130_fd_pr__nfet_01v8 ad=0.1764 pd=1.54 as=0.1764 ps=1.54 w=1.26 l=0.15
X38 a_147_441# a_200_252# a_200_252# a_147_441# sky130_fd_pr__nfet_01v8 ad=0.1764 pd=1.54 as=0.1764 ps=1.54 w=1.26 l=0.15
X39 a_147_441# a_200_252# a_402_441# a_147_441# sky130_fd_pr__nfet_01v8 ad=0.1764 pd=1.54 as=0.1764 ps=1.54 w=1.26 l=0.15
C0 a_402_441# a_200_252# 2.97393f
C1 a_402_441# a_147_441# 8.487219f
C2 a_200_252# a_147_441# 18.3374f
.ends

.subckt TELESCOPIC_OTA_0 IB VCN VOUT VIP VIN VCP VSS VDD
XPMOS_S_77937488_X8_Y1_1774869395_0 li_3071_3091# m1_3150_2912# VDD VSS PMOS_S_77937488_X8_Y1_1774869395
XPMOS_S_77937488_X8_Y1_1774869395_1 li_1695_3091# m1_3150_2912# VDD VSS PMOS_S_77937488_X8_Y1_1774869395
XPMOS_4T_36899923_X2_Y1_1774869394_0 VOUT VCP li_3071_3091# VDD VSS PMOS_4T_36899923_X2_Y1_1774869394
XPMOS_4T_36899923_X2_Y1_1774869394_1 m1_3150_2912# VCP li_1695_3091# VDD VSS PMOS_4T_36899923_X2_Y1_1774869394
XNMOS_4T_27824333_X5_Y1_1774869392_0 li_1351_2839# VIN m1_3354_1316# VSS NMOS_4T_27824333_X5_Y1_1774869392
XNMOS_4T_27824333_X5_Y1_1774869392_1 li_3415_2755# VIP m1_3354_1316# VSS NMOS_4T_27824333_X5_Y1_1774869392
XNMOS_4T_50719370_X4_Y1_1774869393_0 VOUT VCN li_1351_2839# VSS NMOS_4T_50719370_X4_Y1_1774869393
XNMOS_4T_50719370_X4_Y1_1774869393_1 m1_3150_2912# VCN li_3415_2755# VSS NMOS_4T_50719370_X4_Y1_1774869393
XSCM_NMOS_14227459_X10_Y1_1774869396_0 m1_3354_1316# IB VSS SCM_NMOS_14227459_X10_Y1_1774869396
R0 VCP.n5 VCP.t7 568.582
R1 VCP.n5 VCP.t4 568.582
R2 VCP.n3 VCP.t5 568.582
R3 VCP.n3 VCP.t6 568.582
R4 VCP.n1 VCP.t2 568.582
R5 VCP.n1 VCP.t1 568.582
R6 VCP.n0 VCP.t0 568.582
R7 VCP.n0 VCP.t3 568.582
R8 VCP.n2 VCP.n0 161.685
R9 VCP VCP.n5 161.493
R10 VCP.n4 VCP.n3 161.3
R11 VCP.n2 VCP.n1 161.3
R12 VCP.n4 VCP.n2 1.15229
R13 VCP VCP.n4 0.192464
R14 VIN.n4 VIN.t2 568.582
R15 VIN.n4 VIN.t1 568.582
R16 VIN.n5 VIN.t6 568.582
R17 VIN.n5 VIN.t4 568.582
R18 VIN.n3 VIN.t3 568.582
R19 VIN.n3 VIN.t9 568.582
R20 VIN.n1 VIN.t7 568.582
R21 VIN.n1 VIN.t5 568.582
R22 VIN.n0 VIN.t0 568.582
R23 VIN.n0 VIN.t8 568.582
R24 VIN.n6 VIN.n4 161.685
R25 VIN.n2 VIN.n0 161.685
R26 VIN.n6 VIN.n5 161.3
R27 VIN VIN.n3 161.3
R28 VIN.n2 VIN.n1 161.3
R29 VIN VIN.n2 0.384429
R30 VIN VIN.n6 0.384429
R31 VSS.n41 VSS.n25 1179.68
R32 VSS.n66 VSS.n65 1179.68
R33 VSS.n84 VSS.n83 1179.68
R34 VSS.n89 VSS.n88 1179.68
R35 VSS.n51 VSS.n49 1179.68
R36 VSS.n88 VSS.n87 1179.3
R37 VSS.n84 VSS.n2 1179.3
R38 VSS.n82 VSS.n7 1179.3
R39 VSS.n79 VSS.n8 1179.3
R40 VSS.n76 VSS.n9 1179.3
R41 VSS.n72 VSS.n71 1179.3
R42 VSS.n70 VSS.n69 1179.3
R43 VSS.n66 VSS.n11 1179.3
R44 VSS.n64 VSS.n16 1179.3
R45 VSS.n61 VSS.n17 1179.3
R46 VSS.n58 VSS.n18 1179.3
R47 VSS.n30 VSS.n28 1179.3
R48 VSS.n36 VSS.n35 1179.3
R49 VSS.n37 VSS.n25 1179.3
R50 VSS.n40 VSS.n38 1179.3
R51 VSS.n43 VSS.n23 1179.3
R52 VSS.n48 VSS.n47 1179.3
R53 VSS.n54 VSS.n49 1179.3
R54 VSS.n83 VSS.n82 1179.3
R55 VSS.n79 VSS.n5 1179.3
R56 VSS.n76 VSS.n75 1179.3
R57 VSS.n65 VSS.n64 1179.3
R58 VSS.n61 VSS.n14 1179.3
R59 VSS.n58 VSS.n57 1179.3
R60 VSS.n41 VSS.n40 1179.3
R61 VSS.n43 VSS.n42 1179.3
R62 VSS.n47 VSS.n21 1179.3
R63 VSS.n55 VSS.n54 1179.3
R64 VSS.n91 VSS.n90 627.455
R65 VSS.n3 VSS.n1 120.433
R66 VSS.n86 VSS.n85 120.433
R67 VSS.n6 VSS.n4 120.433
R68 VSS.n81 VSS.n80 120.433
R69 VSS.n78 VSS.n77 120.433
R70 VSS.n74 VSS.n73 120.433
R71 VSS.n12 VSS.n10 120.433
R72 VSS.n68 VSS.n67 120.433
R73 VSS.n15 VSS.n13 120.433
R74 VSS.n63 VSS.n62 120.433
R75 VSS.n60 VSS.n59 120.433
R76 VSS.n29 VSS.n19 120.433
R77 VSS.n32 VSS.n31 120.433
R78 VSS.n34 VSS.n33 120.433
R79 VSS.n27 VSS.n26 120.433
R80 VSS.n39 VSS.n24 120.433
R81 VSS.n45 VSS.n44 120.433
R82 VSS.n46 VSS.n22 120.433
R83 VSS.n53 VSS.n52 120.433
R84 VSS.n90 VSS.n89 60.2169
R85 VSS.n89 VSS.n1 60.2169
R86 VSS.n87 VSS.n3 60.2169
R87 VSS.n87 VSS.n86 60.2169
R88 VSS.n85 VSS.n84 60.2169
R89 VSS.n84 VSS.n4 60.2169
R90 VSS.n82 VSS.n6 60.2169
R91 VSS.n82 VSS.n81 60.2169
R92 VSS.n80 VSS.n79 60.2169
R93 VSS.n79 VSS.n78 60.2169
R94 VSS.n77 VSS.n76 60.2169
R95 VSS.n76 VSS.n74 60.2169
R96 VSS.n73 VSS.n72 60.2169
R97 VSS.n72 VSS.n10 60.2169
R98 VSS.n69 VSS.n12 60.2169
R99 VSS.n69 VSS.n68 60.2169
R100 VSS.n67 VSS.n66 60.2169
R101 VSS.n66 VSS.n13 60.2169
R102 VSS.n64 VSS.n15 60.2169
R103 VSS.n64 VSS.n63 60.2169
R104 VSS.n62 VSS.n61 60.2169
R105 VSS.n61 VSS.n60 60.2169
R106 VSS.n59 VSS.n58 60.2169
R107 VSS.n58 VSS.n19 60.2169
R108 VSS.n30 VSS.n29 60.2169
R109 VSS.n31 VSS.n30 60.2169
R110 VSS.n35 VSS.n32 60.2169
R111 VSS.n35 VSS.n34 60.2169
R112 VSS.n33 VSS.n25 60.2169
R113 VSS.n26 VSS.n25 60.2169
R114 VSS.n40 VSS.n27 60.2169
R115 VSS.n40 VSS.n39 60.2169
R116 VSS.n43 VSS.n24 60.2169
R117 VSS.n44 VSS.n43 60.2169
R118 VSS.n47 VSS.n45 60.2169
R119 VSS.n47 VSS.n46 60.2169
R120 VSS.n54 VSS.n22 60.2169
R121 VSS.n54 VSS.n53 60.2169
R122 VSS.n52 VSS.n51 60.2169
R123 VSS.n51 VSS.n50 60.2169
R124 VSS.n56 VSS.n55 8.45167
R125 VSS.n57 VSS.n56 8.098
R126 VSS.n75 VSS.n0 8.098
R127 VSS VSS.n16 7.5005
R128 VSS.n20 VSS 3.973
R129 VSS VSS.n91 3.89107
R130 VSS.n42 VSS.n41 0.384429
R131 VSS.n42 VSS.n21 0.384429
R132 VSS.n55 VSS.n21 0.384429
R133 VSS.n65 VSS.n14 0.384429
R134 VSS.n57 VSS.n14 0.384429
R135 VSS.n83 VSS.n5 0.384429
R136 VSS.n75 VSS.n5 0.384429
R137 VSS.n88 VSS.n2 0.384429
R138 VSS.n7 VSS.n2 0.384429
R139 VSS.n8 VSS.n7 0.384429
R140 VSS.n9 VSS.n8 0.384429
R141 VSS.n71 VSS.n9 0.384429
R142 VSS.n71 VSS.n70 0.384429
R143 VSS.n70 VSS.n11 0.384429
R144 VSS.n16 VSS.n11 0.384429
R145 VSS.n17 VSS.n16 0.384429
R146 VSS.n18 VSS.n17 0.384429
R147 VSS.n28 VSS.n18 0.384429
R148 VSS.n36 VSS.n28 0.384429
R149 VSS.n37 VSS.n36 0.384429
R150 VSS.n38 VSS.n37 0.384429
R151 VSS.n38 VSS.n23 0.384429
R152 VSS.n48 VSS.n23 0.384429
R153 VSS.n49 VSS.n48 0.384429
R154 VSS.n91 VSS.n0 0.30365
R155 VSS.n20 VSS.n0 0.2026
R156 VSS.n56 VSS.n20 0.10155
R157 VIP.n4 VIP.t8 568.582
R158 VIP.n4 VIP.t0 568.582
R159 VIP.n5 VIP.t5 568.582
R160 VIP.n5 VIP.t7 568.582
R161 VIP.n3 VIP.t9 568.582
R162 VIP.n3 VIP.t3 568.582
R163 VIP.n1 VIP.t4 568.582
R164 VIP.n1 VIP.t6 568.582
R165 VIP.n0 VIP.t1 568.582
R166 VIP.n0 VIP.t2 568.582
R167 VIP.n6 VIP.n4 161.685
R168 VIP.n2 VIP.n0 161.685
R169 VIP.n6 VIP.n5 161.3
R170 VIP VIP.n3 161.3
R171 VIP.n2 VIP.n1 161.3
R172 VIP VIP.n2 0.384429
R173 VIP VIP.n6 0.384429
R174 VCN.n11 VCN.t1 568.582
R175 VCN.n11 VCN.t0 568.582
R176 VCN.n12 VCN.t5 568.582
R177 VCN.n12 VCN.t3 568.582
R178 VCN.n9 VCN.t2 568.582
R179 VCN.n9 VCN.t7 568.582
R180 VCN.n7 VCN.t6 568.582
R181 VCN.n7 VCN.t4 568.582
R182 VCN.n5 VCN.t12 568.582
R183 VCN.n5 VCN.t14 568.582
R184 VCN.n3 VCN.t15 568.582
R185 VCN.n3 VCN.t10 568.582
R186 VCN.n1 VCN.t11 568.582
R187 VCN.n1 VCN.t13 568.582
R188 VCN.n0 VCN.t8 568.582
R189 VCN.n0 VCN.t9 568.582
R190 VCN.n13 VCN.n11 161.685
R191 VCN.n2 VCN.n0 161.685
R192 VCN.n13 VCN.n12 161.3
R193 VCN.n10 VCN.n9 161.3
R194 VCN.n8 VCN.n7 161.3
R195 VCN.n6 VCN.n5 161.3
R196 VCN.n4 VCN.n3 161.3
R197 VCN.n2 VCN.n1 161.3
R198 VCN.n8 VCN.n6 1.15229
R199 VCN.n4 VCN.n2 0.384429
R200 VCN.n6 VCN.n4 0.384429
R201 VCN.n10 VCN.n8 0.384429
R202 VCN VCN.n10 0.192464
R203 VCN VCN.n13 0.192464
R204 IB.n86 IB.t30 573.581
R205 IB.n84 IB.t28 573.581
R206 IB.n91 IB.t48 573.581
R207 IB.n89 IB.t54 573.581
R208 IB.n97 IB.t58 573.581
R209 IB.n95 IB.t42 573.581
R210 IB.n103 IB.t14 573.581
R211 IB.n101 IB.t8 573.581
R212 IB.n109 IB.t6 573.581
R213 IB.n107 IB.t38 573.581
R214 IB.n115 IB.t46 573.581
R215 IB.n113 IB.t51 573.581
R216 IB.n121 IB.t57 573.581
R217 IB.n119 IB.t40 573.581
R218 IB.n127 IB.t22 573.581
R219 IB.n125 IB.t20 573.581
R220 IB.n133 IB.t12 573.581
R221 IB.n131 IB.t2 573.581
R222 IB.n81 IB.t41 573.581
R223 IB.n79 IB.t47 573.581
R224 IB.n75 IB.t52 573.581
R225 IB.n73 IB.t53 573.581
R226 IB.n69 IB.t10 573.581
R227 IB.n67 IB.t0 573.581
R228 IB.n63 IB.t26 573.581
R229 IB.n61 IB.t18 573.581
R230 IB.n57 IB.t55 573.581
R231 IB.n55 IB.t59 573.581
R232 IB.n51 IB.t43 573.581
R233 IB.n49 IB.t44 573.581
R234 IB.n45 IB.t16 573.581
R235 IB.n43 IB.t4 573.581
R236 IB.n39 IB.t36 573.581
R237 IB.n37 IB.t34 573.581
R238 IB.n33 IB.t45 573.581
R239 IB.n31 IB.t49 573.581
R240 IB.n27 IB.t50 573.581
R241 IB.n25 IB.t56 573.581
R242 IB.n22 IB.t32 573.581
R243 IB.n20 IB.t24 573.581
R244 IB.n2 IB.n0 180.853
R245 IB.n11 IB.n9 180.852
R246 IB.n11 IB.n10 179.702
R247 IB.n13 IB.n12 179.702
R248 IB.n15 IB.n14 179.702
R249 IB.n17 IB.n16 179.702
R250 IB.n8 IB.n7 179.702
R251 IB.n6 IB.n5 179.702
R252 IB.n4 IB.n3 179.702
R253 IB.n2 IB.n1 179.702
R254 IB.n93 IB.n87 161.685
R255 IB.n29 IB.n23 161.685
R256 IB.n93 IB.n92 161.3
R257 IB.n99 IB.n98 161.3
R258 IB.n105 IB.n104 161.3
R259 IB.n111 IB.n110 161.3
R260 IB.n117 IB.n116 161.3
R261 IB.n123 IB.n122 161.3
R262 IB.n129 IB.n128 161.3
R263 IB.n135 IB.n134 161.3
R264 IB.n136 IB.n82 161.3
R265 IB.n77 IB.n76 161.3
R266 IB.n71 IB.n70 161.3
R267 IB.n65 IB.n64 161.3
R268 IB.n59 IB.n58 161.3
R269 IB.n53 IB.n52 161.3
R270 IB.n47 IB.n46 161.3
R271 IB.n41 IB.n40 161.3
R272 IB.n35 IB.n34 161.3
R273 IB.n29 IB.n28 161.3
R274 IB.n86 IB.n85 33.7405
R275 IB.n84 IB.n83 33.7405
R276 IB.n91 IB.n90 33.7405
R277 IB.n89 IB.n88 33.7405
R278 IB.n97 IB.n96 33.7405
R279 IB.n95 IB.n94 33.7405
R280 IB.n103 IB.n102 33.7405
R281 IB.n101 IB.n100 33.7405
R282 IB.n109 IB.n108 33.7405
R283 IB.n107 IB.n106 33.7405
R284 IB.n115 IB.n114 33.7405
R285 IB.n113 IB.n112 33.7405
R286 IB.n121 IB.n120 33.7405
R287 IB.n119 IB.n118 33.7405
R288 IB.n127 IB.n126 33.7405
R289 IB.n125 IB.n124 33.7405
R290 IB.n133 IB.n132 33.7405
R291 IB.n131 IB.n130 33.7405
R292 IB.n81 IB.n80 33.7405
R293 IB.n79 IB.n78 33.7405
R294 IB.n75 IB.n74 33.7405
R295 IB.n73 IB.n72 33.7405
R296 IB.n69 IB.n68 33.7405
R297 IB.n67 IB.n66 33.7405
R298 IB.n63 IB.n62 33.7405
R299 IB.n61 IB.n60 33.7405
R300 IB.n57 IB.n56 33.7405
R301 IB.n55 IB.n54 33.7405
R302 IB.n51 IB.n50 33.7405
R303 IB.n49 IB.n48 33.7405
R304 IB.n45 IB.n44 33.7405
R305 IB.n43 IB.n42 33.7405
R306 IB.n39 IB.n38 33.7405
R307 IB.n37 IB.n36 33.7405
R308 IB.n33 IB.n32 33.7405
R309 IB.n31 IB.n30 33.7405
R310 IB.n27 IB.n26 33.7405
R311 IB.n25 IB.n24 33.7405
R312 IB.n22 IB.n21 33.7405
R313 IB.n20 IB.n19 33.7405
R314 IB.n87 IB.n84 24.9931
R315 IB.n87 IB.n86 24.9931
R316 IB.n92 IB.n89 24.9931
R317 IB.n92 IB.n91 24.9931
R318 IB.n98 IB.n95 24.9931
R319 IB.n98 IB.n97 24.9931
R320 IB.n104 IB.n101 24.9931
R321 IB.n104 IB.n103 24.9931
R322 IB.n110 IB.n107 24.9931
R323 IB.n110 IB.n109 24.9931
R324 IB.n116 IB.n113 24.9931
R325 IB.n116 IB.n115 24.9931
R326 IB.n122 IB.n119 24.9931
R327 IB.n122 IB.n121 24.9931
R328 IB.n128 IB.n125 24.9931
R329 IB.n128 IB.n127 24.9931
R330 IB.n134 IB.n131 24.9931
R331 IB.n134 IB.n133 24.9931
R332 IB.n82 IB.n79 24.9931
R333 IB.n82 IB.n81 24.9931
R334 IB.n76 IB.n73 24.9931
R335 IB.n76 IB.n75 24.9931
R336 IB.n70 IB.n67 24.9931
R337 IB.n70 IB.n69 24.9931
R338 IB.n64 IB.n61 24.9931
R339 IB.n64 IB.n63 24.9931
R340 IB.n58 IB.n55 24.9931
R341 IB.n58 IB.n57 24.9931
R342 IB.n52 IB.n49 24.9931
R343 IB.n52 IB.n51 24.9931
R344 IB.n46 IB.n43 24.9931
R345 IB.n46 IB.n45 24.9931
R346 IB.n40 IB.n37 24.9931
R347 IB.n40 IB.n39 24.9931
R348 IB.n34 IB.n31 24.9931
R349 IB.n34 IB.n33 24.9931
R350 IB.n28 IB.n25 24.9931
R351 IB.n28 IB.n27 24.9931
R352 IB.n23 IB.n20 24.9931
R353 IB.n23 IB.n22 24.9931
R354 IB.n9 IB.t29 13.3338
R355 IB.n9 IB.t31 13.3338
R356 IB.n10 IB.t9 13.3338
R357 IB.n10 IB.t15 13.3338
R358 IB.n12 IB.t39 13.3338
R359 IB.n12 IB.t7 13.3338
R360 IB.n14 IB.t21 13.3338
R361 IB.n14 IB.t23 13.3338
R362 IB.n16 IB.t3 13.3338
R363 IB.n16 IB.t13 13.3338
R364 IB.n7 IB.t1 13.3338
R365 IB.n7 IB.t11 13.3338
R366 IB.n5 IB.t19 13.3338
R367 IB.n5 IB.t27 13.3338
R368 IB.n3 IB.t5 13.3338
R369 IB.n3 IB.t17 13.3338
R370 IB.n1 IB.t35 13.3338
R371 IB.n1 IB.t37 13.3338
R372 IB.n0 IB.t25 13.3338
R373 IB.n0 IB.t33 13.3338
R374 IB IB.n18 5.438
R375 IB IB.n136 5.438
R376 IB.n6 IB.n4 1.15229
R377 IB.n15 IB.n13 1.15229
R378 IB.n18 IB.n8 0.768357
R379 IB.n35 IB.n29 0.384429
R380 IB.n41 IB.n35 0.384429
R381 IB.n47 IB.n41 0.384429
R382 IB.n53 IB.n47 0.384429
R383 IB.n59 IB.n53 0.384429
R384 IB.n65 IB.n59 0.384429
R385 IB.n71 IB.n65 0.384429
R386 IB.n77 IB.n71 0.384429
R387 IB.n136 IB.n77 0.384429
R388 IB.n136 IB.n135 0.384429
R389 IB.n135 IB.n129 0.384429
R390 IB.n129 IB.n123 0.384429
R391 IB.n123 IB.n117 0.384429
R392 IB.n117 IB.n111 0.384429
R393 IB.n111 IB.n105 0.384429
R394 IB.n105 IB.n99 0.384429
R395 IB.n99 IB.n93 0.384429
R396 IB.n4 IB.n2 0.384429
R397 IB.n8 IB.n6 0.384429
R398 IB.n18 IB.n17 0.384429
R399 IB.n17 IB.n15 0.384429
R400 IB.n13 IB.n11 0.384429
C0 IB VIN 0.011665f
C1 VIN li_1695_3091# 0.00215f
C2 li_3415_2755# m1_3150_2912# 0.108311f
C3 li_3415_2755# m1_3354_1316# 0.451118f
C4 VDD VCN 0.13713f
C5 VDD IB 0.35043f
C6 VDD li_1695_3091# 0.378608f
C7 li_3415_2755# li_1351_2839# 0.061836f
C8 VDD VIP 0.039315f
C9 VIN m1_3150_2912# 0.009524f
C10 VDD li_3071_3091# 0.49383f
C11 VDD VCP 0.47021f
C12 li_3415_2755# VOUT 0.005207f
C13 VIN m1_3354_1316# 0.067453f
C14 VDD m1_3150_2912# 1.406915f
C15 VCN IB 0.048733f
C16 VCN li_1695_3091# 8.92e-19
C17 VIN li_1351_2839# 0.001517f
C18 VDD m1_3354_1316# 0.265296f
C19 VCN VIP 0.034325f
C20 VCN li_3071_3091# 8.92e-19
C21 VCN VCP 0.007619f
C22 VDD li_1351_2839# 0.175647f
C23 li_3071_3091# li_1695_3091# 0.060882f
C24 VCP li_1695_3091# 0.00226f
C25 VDD VOUT 0.190815f
C26 li_3071_3091# VIP 0.00215f
C27 VCN m1_3150_2912# 0.006997f
C28 VCP li_3071_3091# 0.011482f
C29 IB m1_3150_2912# 2.36e-20
C30 m1_3150_2912# li_1695_3091# 0.525456f
C31 VCN m1_3354_1316# 0.064324f
C32 IB m1_3354_1316# 0.184682f
C33 li_1695_3091# m1_3354_1316# 0.019521f
C34 m1_3150_2912# VIP 0.009524f
C35 m1_3150_2912# li_3071_3091# 0.232684f
C36 VCP m1_3150_2912# 0.159018f
C37 VCN li_1351_2839# 0.011482f
C38 m1_3354_1316# VIP 0.037735f
C39 li_3071_3091# m1_3354_1316# 0.01966f
C40 IB li_1351_2839# 0.01143f
C41 VCN VOUT 0.011069f
C42 li_1351_2839# li_1695_3091# 0.49221f
C43 IB VOUT 0.001948f
C44 VOUT li_1695_3091# 0.078904f
C45 VDD li_3415_2755# 0.134338f
C46 VCP li_1351_2839# 3.6e-19
C47 m1_3150_2912# m1_3354_1316# 0.020606f
C48 VOUT li_3071_3091# 0.04967f
C49 VCP VOUT 0.002006f
C50 m1_3150_2912# li_1351_2839# 0.005028f
C51 m1_3150_2912# VOUT 0.584284f
C52 li_1351_2839# m1_3354_1316# 0.183962f
C53 VDD VIN 0.040549f
C54 VCN li_3415_2755# 0.016482f
C55 VOUT m1_3354_1316# 0.012924f
C56 IB li_3415_2755# 0.008967f
C57 VOUT li_1351_2839# 0.087273f
C58 li_3415_2755# VIP 0.002694f
C59 li_3415_2755# li_3071_3091# 0.379951f
C60 VCP li_3415_2755# 3.6e-19
C61 VCN VIN 0.034325f
C62 VCN VSS 3.771911f
C63 m1_3150_2912# VSS 1.161313f
C64 IB.t25 VSS 0.006602f
C65 IB.t33 VSS 0.006602f
C66 IB.n0 VSS 0.044733f
C67 IB.t35 VSS 0.006602f
C68 IB.t37 VSS 0.006602f
C69 IB.n1 VSS 0.044315f
C70 IB.n2 VSS 0.13612f
C71 IB.t5 VSS 0.006602f
C72 IB.t17 VSS 0.006602f
C73 IB.n3 VSS 0.044315f
C74 IB.n4 VSS 0.070993f
C75 IB.t19 VSS 0.006602f
C76 IB.t27 VSS 0.006602f
C77 IB.n5 VSS 0.044315f
C78 IB.n6 VSS 0.070993f
C79 IB.t1 VSS 0.006602f
C80 IB.t11 VSS 0.006602f
C81 IB.n7 VSS 0.044315f
C82 IB.n8 VSS 0.061981f
C83 IB.t29 VSS 0.006602f
C84 IB.t31 VSS 0.006602f
C85 IB.n9 VSS 0.044733f
C86 IB.t9 VSS 0.006602f
C87 IB.t15 VSS 0.006602f
C88 IB.n10 VSS 0.044315f
C89 IB.n11 VSS 0.136119f
C90 IB.t39 VSS 0.006602f
C91 IB.t7 VSS 0.006602f
C92 IB.n12 VSS 0.044315f
C93 IB.n13 VSS 0.070993f
C94 IB.t21 VSS 0.006602f
C95 IB.t23 VSS 0.006602f
C96 IB.n14 VSS 0.044315f
C97 IB.n15 VSS 0.070993f
C98 IB.t3 VSS 0.006602f
C99 IB.t13 VSS 0.006602f
C100 IB.n16 VSS 0.044315f
C101 IB.n17 VSS 0.052969f
C102 IB.n18 VSS 0.031409f
C103 IB.t24 VSS 0.006484f
C104 IB.n19 VSS 0.007663f
C105 IB.n20 VSS 0.012025f
C106 IB.t32 VSS 0.006484f
C107 IB.n21 VSS 0.007663f
C108 IB.n22 VSS 0.012025f
C109 IB.n23 VSS 0.003991f
C110 IB.t56 VSS 0.006484f
C111 IB.n24 VSS 0.007663f
C112 IB.n25 VSS 0.012025f
C113 IB.t50 VSS 0.006484f
C114 IB.n26 VSS 0.007663f
C115 IB.n27 VSS 0.012025f
C116 IB.n28 VSS 0.003919f
C117 IB.n29 VSS 0.066148f
C118 IB.t49 VSS 0.006484f
C119 IB.n30 VSS 0.007663f
C120 IB.n31 VSS 0.012025f
C121 IB.t45 VSS 0.006484f
C122 IB.n32 VSS 0.007663f
C123 IB.n33 VSS 0.012025f
C124 IB.n34 VSS 0.003919f
C125 IB.n35 VSS 0.035834f
C126 IB.t34 VSS 0.006484f
C127 IB.n36 VSS 0.007663f
C128 IB.n37 VSS 0.012025f
C129 IB.t36 VSS 0.006484f
C130 IB.n38 VSS 0.007663f
C131 IB.n39 VSS 0.012025f
C132 IB.n40 VSS 0.003919f
C133 IB.n41 VSS 0.035834f
C134 IB.t4 VSS 0.006484f
C135 IB.n42 VSS 0.007663f
C136 IB.n43 VSS 0.012025f
C137 IB.t16 VSS 0.006484f
C138 IB.n44 VSS 0.007663f
C139 IB.n45 VSS 0.012025f
C140 IB.n46 VSS 0.003919f
C141 IB.n47 VSS 0.035834f
C142 IB.t44 VSS 0.006484f
C143 IB.n48 VSS 0.007663f
C144 IB.n49 VSS 0.012025f
C145 IB.t43 VSS 0.006484f
C146 IB.n50 VSS 0.007663f
C147 IB.n51 VSS 0.012025f
C148 IB.n52 VSS 0.003919f
C149 IB.n53 VSS 0.035834f
C150 IB.t59 VSS 0.006484f
C151 IB.n54 VSS 0.007663f
C152 IB.n55 VSS 0.012025f
C153 IB.t55 VSS 0.006484f
C154 IB.n56 VSS 0.007663f
C155 IB.n57 VSS 0.012025f
C156 IB.n58 VSS 0.003919f
C157 IB.n59 VSS 0.035834f
C158 IB.t18 VSS 0.006484f
C159 IB.n60 VSS 0.007663f
C160 IB.n61 VSS 0.012025f
C161 IB.t26 VSS 0.006484f
C162 IB.n62 VSS 0.007663f
C163 IB.n63 VSS 0.012025f
C164 IB.n64 VSS 0.003919f
C165 IB.n65 VSS 0.035834f
C166 IB.t0 VSS 0.006484f
C167 IB.n66 VSS 0.007663f
C168 IB.n67 VSS 0.012025f
C169 IB.t10 VSS 0.006484f
C170 IB.n68 VSS 0.007663f
C171 IB.n69 VSS 0.012025f
C172 IB.n70 VSS 0.003919f
C173 IB.n71 VSS 0.035834f
C174 IB.t53 VSS 0.006484f
C175 IB.n72 VSS 0.007663f
C176 IB.n73 VSS 0.012025f
C177 IB.t52 VSS 0.006484f
C178 IB.n74 VSS 0.007663f
C179 IB.n75 VSS 0.012025f
C180 IB.n76 VSS 0.003919f
C181 IB.n77 VSS 0.035834f
C182 IB.t47 VSS 0.006484f
C183 IB.n78 VSS 0.007663f
C184 IB.n79 VSS 0.012025f
C185 IB.t41 VSS 0.006484f
C186 IB.n80 VSS 0.007663f
C187 IB.n81 VSS 0.012025f
C188 IB.n82 VSS 0.003919f
C189 IB.t28 VSS 0.006484f
C190 IB.n83 VSS 0.007663f
C191 IB.n84 VSS 0.012025f
C192 IB.t30 VSS 0.006484f
C193 IB.n85 VSS 0.007663f
C194 IB.n86 VSS 0.012025f
C195 IB.n87 VSS 0.003991f
C196 IB.t54 VSS 0.006484f
C197 IB.n88 VSS 0.007663f
C198 IB.n89 VSS 0.012025f
C199 IB.t48 VSS 0.006484f
C200 IB.n90 VSS 0.007663f
C201 IB.n91 VSS 0.012025f
C202 IB.n92 VSS 0.003919f
C203 IB.n93 VSS 0.066148f
C204 IB.t42 VSS 0.006484f
C205 IB.n94 VSS 0.007663f
C206 IB.n95 VSS 0.012025f
C207 IB.t58 VSS 0.006484f
C208 IB.n96 VSS 0.007663f
C209 IB.n97 VSS 0.012025f
C210 IB.n98 VSS 0.003919f
C211 IB.n99 VSS 0.035834f
C212 IB.t8 VSS 0.006484f
C213 IB.n100 VSS 0.007663f
C214 IB.n101 VSS 0.012025f
C215 IB.t14 VSS 0.006484f
C216 IB.n102 VSS 0.007663f
C217 IB.n103 VSS 0.012025f
C218 IB.n104 VSS 0.003919f
C219 IB.n105 VSS 0.035834f
C220 IB.t38 VSS 0.006484f
C221 IB.n106 VSS 0.007663f
C222 IB.n107 VSS 0.012025f
C223 IB.t6 VSS 0.006484f
C224 IB.n108 VSS 0.007663f
C225 IB.n109 VSS 0.012025f
C226 IB.n110 VSS 0.003919f
C227 IB.n111 VSS 0.035834f
C228 IB.t51 VSS 0.006484f
C229 IB.n112 VSS 0.007663f
C230 IB.n113 VSS 0.012025f
C231 IB.t46 VSS 0.006484f
C232 IB.n114 VSS 0.007663f
C233 IB.n115 VSS 0.012025f
C234 IB.n116 VSS 0.003919f
C235 IB.n117 VSS 0.035834f
C236 IB.t40 VSS 0.006484f
C237 IB.n118 VSS 0.007663f
C238 IB.n119 VSS 0.012025f
C239 IB.t57 VSS 0.006484f
C240 IB.n120 VSS 0.007663f
C241 IB.n121 VSS 0.012025f
C242 IB.n122 VSS 0.003919f
C243 IB.n123 VSS 0.035834f
C244 IB.t20 VSS 0.006484f
C245 IB.n124 VSS 0.007663f
C246 IB.n125 VSS 0.012025f
C247 IB.t22 VSS 0.006484f
C248 IB.n126 VSS 0.007663f
C249 IB.n127 VSS 0.012025f
C250 IB.n128 VSS 0.003919f
C251 IB.n129 VSS 0.035834f
C252 IB.t2 VSS 0.006484f
C253 IB.n130 VSS 0.007663f
C254 IB.n131 VSS 0.012025f
C255 IB.t12 VSS 0.006484f
C256 IB.n132 VSS 0.007663f
C257 IB.n133 VSS 0.012025f
C258 IB.n134 VSS 0.003919f
C259 IB.n135 VSS 0.035834f
C260 IB.n136 VSS 0.040207f
C261 VCP.t3 VSS 0.04081f
C262 VCP.t0 VSS 0.04081f
C263 VCP.n0 VSS 0.18339f
C264 VCP.t1 VSS 0.04081f
C265 VCP.t2 VSS 0.04081f
C266 VCP.n1 VSS 0.182944f
C267 VCP.n2 VSS 0.520427f
C268 VCP.t6 VSS 0.04081f
C269 VCP.t5 VSS 0.04081f
C270 VCP.n3 VSS 0.182944f
C271 VCP.n4 VSS 0.305143f
C272 VCP.t4 VSS 0.04081f
C273 VCP.t7 VSS 0.04081f
C274 VCP.n5 VSS 0.183134f
C275 IB VSS 18.79685f
C276 li_3415_2755# VSS 0.760723f
C277 li_1351_2839# VSS 0.804285f
C278 VIP VSS 2.313189f
C279 m1_3354_1316# VSS 10.975927f
C280 VIN VSS 2.302066f
C281 li_1695_3091# VSS 0.1315f
C282 VDD VSS 52.37983f
C283 VOUT VSS 3.093055f
C284 li_3071_3091# VSS 0.149129f
C285 VCP VSS 0.40952f
.ends
