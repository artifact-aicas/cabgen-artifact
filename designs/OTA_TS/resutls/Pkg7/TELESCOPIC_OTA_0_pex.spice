* NGSPICE file created from TELESCOPIC_OTA_0.ext - technology: sky130A

.subckt PMOS_4T_48128194_X4_Y1_1774869455 a_230_420# a_200_252# a_147_420# w_0_0#
+ VSUBS
X0 a_230_420# a_200_252# a_147_420# w_0_0# sky130_fd_pr__pfet_01v8 ad=0.2058 pd=1.75 as=0.2058 ps=1.75 w=1.47 l=0.15
X1 a_230_420# a_200_252# a_147_420# w_0_0# sky130_fd_pr__pfet_01v8 ad=0.2058 pd=1.75 as=0.38955 ps=3.47 w=1.47 l=0.15
X2 a_147_420# a_200_252# a_230_420# w_0_0# sky130_fd_pr__pfet_01v8 ad=0.2058 pd=1.75 as=0.2058 ps=1.75 w=1.47 l=0.15
X3 a_147_420# a_200_252# a_230_420# w_0_0# sky130_fd_pr__pfet_01v8 ad=0.2058 pd=1.75 as=0.2058 ps=1.75 w=1.47 l=0.15
X4 a_230_420# a_200_252# a_147_420# w_0_0# sky130_fd_pr__pfet_01v8 ad=0.2058 pd=1.75 as=0.2058 ps=1.75 w=1.47 l=0.15
X5 a_230_420# a_200_252# a_147_420# w_0_0# sky130_fd_pr__pfet_01v8 ad=0.2058 pd=1.75 as=0.2058 ps=1.75 w=1.47 l=0.15
X6 a_147_420# a_200_252# a_230_420# w_0_0# sky130_fd_pr__pfet_01v8 ad=0.2058 pd=1.75 as=0.2058 ps=1.75 w=1.47 l=0.15
X7 a_147_420# a_200_252# a_230_420# w_0_0# sky130_fd_pr__pfet_01v8 ad=0.38955 pd=3.47 as=0.2058 ps=1.75 w=1.47 l=0.15
C0 a_147_420# a_200_252# 0.34292f
C1 a_147_420# w_0_0# 0.307435f
C2 a_147_420# a_230_420# 2.75841f
C3 w_0_0# a_200_252# 1.46253f
C4 a_200_252# a_230_420# 0.347594f
C5 w_0_0# a_230_420# 0.143535f
C6 a_230_420# VSUBS 0.161483f
C7 a_147_420# VSUBS 0.288894f
C8 a_200_252# VSUBS 0.288346f
C9 w_0_0# VSUBS 4.84666f
.ends

.subckt NMOS_4T_31167546_X10_Y1_1774869453 a_230_420# a_200_252# a_147_420# a_241_1232#
X0 a_147_420# a_200_252# a_230_420# a_241_1232# sky130_fd_pr__nfet_01v8 ad=0.2058 pd=1.75 as=0.2058 ps=1.75 w=1.47 l=0.15
X1 a_147_420# a_200_252# a_230_420# a_241_1232# sky130_fd_pr__nfet_01v8 ad=0.2058 pd=1.75 as=0.2058 ps=1.75 w=1.47 l=0.15
X2 a_230_420# a_200_252# a_147_420# a_241_1232# sky130_fd_pr__nfet_01v8 ad=0.2058 pd=1.75 as=0.2058 ps=1.75 w=1.47 l=0.15
X3 a_230_420# a_200_252# a_147_420# a_241_1232# sky130_fd_pr__nfet_01v8 ad=0.2058 pd=1.75 as=0.2058 ps=1.75 w=1.47 l=0.15
X4 a_147_420# a_200_252# a_230_420# a_241_1232# sky130_fd_pr__nfet_01v8 ad=0.2058 pd=1.75 as=0.2058 ps=1.75 w=1.47 l=0.15
X5 a_230_420# a_200_252# a_147_420# a_241_1232# sky130_fd_pr__nfet_01v8 ad=0.2058 pd=1.75 as=0.2058 ps=1.75 w=1.47 l=0.15
X6 a_147_420# a_200_252# a_230_420# a_241_1232# sky130_fd_pr__nfet_01v8 ad=0.2058 pd=1.75 as=0.2058 ps=1.75 w=1.47 l=0.15
X7 a_147_420# a_200_252# a_230_420# a_241_1232# sky130_fd_pr__nfet_01v8 ad=0.2058 pd=1.75 as=0.2058 ps=1.75 w=1.47 l=0.15
X8 a_230_420# a_200_252# a_147_420# a_241_1232# sky130_fd_pr__nfet_01v8 ad=0.2058 pd=1.75 as=0.38955 ps=3.47 w=1.47 l=0.15
X9 a_230_420# a_200_252# a_147_420# a_241_1232# sky130_fd_pr__nfet_01v8 ad=0.2058 pd=1.75 as=0.2058 ps=1.75 w=1.47 l=0.15
X10 a_147_420# a_200_252# a_230_420# a_241_1232# sky130_fd_pr__nfet_01v8 ad=0.2058 pd=1.75 as=0.2058 ps=1.75 w=1.47 l=0.15
X11 a_147_420# a_200_252# a_230_420# a_241_1232# sky130_fd_pr__nfet_01v8 ad=0.2058 pd=1.75 as=0.2058 ps=1.75 w=1.47 l=0.15
X12 a_230_420# a_200_252# a_147_420# a_241_1232# sky130_fd_pr__nfet_01v8 ad=0.2058 pd=1.75 as=0.2058 ps=1.75 w=1.47 l=0.15
X13 a_147_420# a_200_252# a_230_420# a_241_1232# sky130_fd_pr__nfet_01v8 ad=0.2058 pd=1.75 as=0.2058 ps=1.75 w=1.47 l=0.15
X14 a_230_420# a_200_252# a_147_420# a_241_1232# sky130_fd_pr__nfet_01v8 ad=0.2058 pd=1.75 as=0.2058 ps=1.75 w=1.47 l=0.15
X15 a_147_420# a_200_252# a_230_420# a_241_1232# sky130_fd_pr__nfet_01v8 ad=0.38955 pd=3.47 as=0.2058 ps=1.75 w=1.47 l=0.15
X16 a_230_420# a_200_252# a_147_420# a_241_1232# sky130_fd_pr__nfet_01v8 ad=0.2058 pd=1.75 as=0.2058 ps=1.75 w=1.47 l=0.15
X17 a_230_420# a_200_252# a_147_420# a_241_1232# sky130_fd_pr__nfet_01v8 ad=0.2058 pd=1.75 as=0.2058 ps=1.75 w=1.47 l=0.15
X18 a_147_420# a_200_252# a_230_420# a_241_1232# sky130_fd_pr__nfet_01v8 ad=0.2058 pd=1.75 as=0.2058 ps=1.75 w=1.47 l=0.15
X19 a_230_420# a_200_252# a_147_420# a_241_1232# sky130_fd_pr__nfet_01v8 ad=0.2058 pd=1.75 as=0.2058 ps=1.75 w=1.47 l=0.15
C0 a_230_420# a_147_420# 6.99276f
C1 a_230_420# a_200_252# 0.869599f
C2 a_200_252# a_147_420# 0.875174f
C3 a_230_420# a_241_1232# 0.766524f
C4 a_147_420# a_241_1232# 0.900603f
C5 a_200_252# a_241_1232# 4.06728f
.ends

.subckt SCM_NMOS_90644832_X6_Y1_1774869457 a_402_420# a_200_252# a_147_420#
X0 a_147_420# a_200_252# a_402_420# a_147_420# sky130_fd_pr__nfet_01v8 ad=0.2058 pd=1.75 as=0.2058 ps=1.75 w=1.47 l=0.15
X1 a_147_420# a_200_252# a_200_252# a_147_420# sky130_fd_pr__nfet_01v8 ad=0.2058 pd=1.75 as=0.2058 ps=1.75 w=1.47 l=0.15
X2 a_200_252# a_200_252# a_147_420# a_147_420# sky130_fd_pr__nfet_01v8 ad=0.2058 pd=1.75 as=0.2058 ps=1.75 w=1.47 l=0.15
X3 a_402_420# a_200_252# a_147_420# a_147_420# sky130_fd_pr__nfet_01v8 ad=0.2058 pd=1.75 as=0.2058 ps=1.75 w=1.47 l=0.15
X4 a_147_420# a_200_252# a_200_252# a_147_420# sky130_fd_pr__nfet_01v8 ad=0.2058 pd=1.75 as=0.2058 ps=1.75 w=1.47 l=0.15
X5 a_147_420# a_200_252# a_200_252# a_147_420# sky130_fd_pr__nfet_01v8 ad=0.38955 pd=3.47 as=0.2058 ps=1.75 w=1.47 l=0.15
X6 a_402_420# a_200_252# a_147_420# a_147_420# sky130_fd_pr__nfet_01v8 ad=0.2058 pd=1.75 as=0.2058 ps=1.75 w=1.47 l=0.15
X7 a_147_420# a_200_252# a_200_252# a_147_420# sky130_fd_pr__nfet_01v8 ad=0.2058 pd=1.75 as=0.2058 ps=1.75 w=1.47 l=0.15
X8 a_147_420# a_200_252# a_402_420# a_147_420# sky130_fd_pr__nfet_01v8 ad=0.2058 pd=1.75 as=0.2058 ps=1.75 w=1.47 l=0.15
X9 a_200_252# a_200_252# a_147_420# a_147_420# sky130_fd_pr__nfet_01v8 ad=0.2058 pd=1.75 as=0.38955 ps=3.47 w=1.47 l=0.15
X10 a_402_420# a_200_252# a_147_420# a_147_420# sky130_fd_pr__nfet_01v8 ad=0.2058 pd=1.75 as=0.2058 ps=1.75 w=1.47 l=0.15
X11 a_147_420# a_200_252# a_200_252# a_147_420# sky130_fd_pr__nfet_01v8 ad=0.2058 pd=1.75 as=0.2058 ps=1.75 w=1.47 l=0.15
X12 a_147_420# a_200_252# a_402_420# a_147_420# sky130_fd_pr__nfet_01v8 ad=0.2058 pd=1.75 as=0.2058 ps=1.75 w=1.47 l=0.15
X13 a_402_420# a_200_252# a_147_420# a_147_420# sky130_fd_pr__nfet_01v8 ad=0.2058 pd=1.75 as=0.2058 ps=1.75 w=1.47 l=0.15
X14 a_147_420# a_200_252# a_200_252# a_147_420# sky130_fd_pr__nfet_01v8 ad=0.2058 pd=1.75 as=0.2058 ps=1.75 w=1.47 l=0.15
X15 a_200_252# a_200_252# a_147_420# a_147_420# sky130_fd_pr__nfet_01v8 ad=0.2058 pd=1.75 as=0.2058 ps=1.75 w=1.47 l=0.15
X16 a_147_420# a_200_252# a_402_420# a_147_420# sky130_fd_pr__nfet_01v8 ad=0.2058 pd=1.75 as=0.2058 ps=1.75 w=1.47 l=0.15
X17 a_402_420# a_200_252# a_147_420# a_147_420# sky130_fd_pr__nfet_01v8 ad=0.2058 pd=1.75 as=0.2058 ps=1.75 w=1.47 l=0.15
X18 a_200_252# a_200_252# a_147_420# a_147_420# sky130_fd_pr__nfet_01v8 ad=0.2058 pd=1.75 as=0.2058 ps=1.75 w=1.47 l=0.15
X19 a_147_420# a_200_252# a_402_420# a_147_420# sky130_fd_pr__nfet_01v8 ad=0.2058 pd=1.75 as=0.2058 ps=1.75 w=1.47 l=0.15
X20 a_200_252# a_200_252# a_147_420# a_147_420# sky130_fd_pr__nfet_01v8 ad=0.2058 pd=1.75 as=0.2058 ps=1.75 w=1.47 l=0.15
X21 a_402_420# a_200_252# a_147_420# a_147_420# sky130_fd_pr__nfet_01v8 ad=0.2058 pd=1.75 as=0.2058 ps=1.75 w=1.47 l=0.15
X22 a_200_252# a_200_252# a_147_420# a_147_420# sky130_fd_pr__nfet_01v8 ad=0.2058 pd=1.75 as=0.2058 ps=1.75 w=1.47 l=0.15
X23 a_147_420# a_200_252# a_402_420# a_147_420# sky130_fd_pr__nfet_01v8 ad=0.2058 pd=1.75 as=0.2058 ps=1.75 w=1.47 l=0.15
C0 a_200_252# a_402_420# 1.68536f
C1 a_402_420# a_147_420# 4.98082f
C2 a_200_252# a_147_420# 11.030901f
.ends

.subckt NMOS_4T_47642139_X3_Y1_1774869454 a_230_420# a_200_252# a_147_420# a_241_1232#
X0 a_147_420# a_200_252# a_230_420# a_241_1232# sky130_fd_pr__nfet_01v8 ad=0.2058 pd=1.75 as=0.2058 ps=1.75 w=1.47 l=0.15
X1 a_230_420# a_200_252# a_147_420# a_241_1232# sky130_fd_pr__nfet_01v8 ad=0.2058 pd=1.75 as=0.2058 ps=1.75 w=1.47 l=0.15
X2 a_230_420# a_200_252# a_147_420# a_241_1232# sky130_fd_pr__nfet_01v8 ad=0.2058 pd=1.75 as=0.38955 ps=3.47 w=1.47 l=0.15
X3 a_147_420# a_200_252# a_230_420# a_241_1232# sky130_fd_pr__nfet_01v8 ad=0.2058 pd=1.75 as=0.2058 ps=1.75 w=1.47 l=0.15
X4 a_147_420# a_200_252# a_230_420# a_241_1232# sky130_fd_pr__nfet_01v8 ad=0.38955 pd=3.47 as=0.2058 ps=1.75 w=1.47 l=0.15
X5 a_230_420# a_200_252# a_147_420# a_241_1232# sky130_fd_pr__nfet_01v8 ad=0.2058 pd=1.75 as=0.2058 ps=1.75 w=1.47 l=0.15
C0 a_230_420# a_147_420# 2.05269f
C1 a_230_420# a_200_252# 0.260594f
C2 a_200_252# a_147_420# 0.254211f
C3 a_230_420# a_241_1232# 0.2281f
C4 a_147_420# a_241_1232# 0.545616f
C5 a_200_252# a_241_1232# 1.36478f
.ends

.subckt PMOS_S_59459431_X8_Y1_1774869456 a_230_420# a_200_252# w_0_0# VSUBS
X0 a_230_420# a_200_252# w_0_0# w_0_0# sky130_fd_pr__pfet_01v8 ad=0.2058 pd=1.75 as=0.2058 ps=1.75 w=1.47 l=0.15
X1 w_0_0# a_200_252# a_230_420# w_0_0# sky130_fd_pr__pfet_01v8 ad=0.2058 pd=1.75 as=0.2058 ps=1.75 w=1.47 l=0.15
X2 w_0_0# a_200_252# a_230_420# w_0_0# sky130_fd_pr__pfet_01v8 ad=0.2058 pd=1.75 as=0.2058 ps=1.75 w=1.47 l=0.15
X3 a_230_420# a_200_252# w_0_0# w_0_0# sky130_fd_pr__pfet_01v8 ad=0.2058 pd=1.75 as=0.38955 ps=3.47 w=1.47 l=0.15
X4 w_0_0# a_200_252# a_230_420# w_0_0# sky130_fd_pr__pfet_01v8 ad=0.2058 pd=1.75 as=0.2058 ps=1.75 w=1.47 l=0.15
X5 w_0_0# a_200_252# a_230_420# w_0_0# sky130_fd_pr__pfet_01v8 ad=0.2058 pd=1.75 as=0.2058 ps=1.75 w=1.47 l=0.15
X6 a_230_420# a_200_252# w_0_0# w_0_0# sky130_fd_pr__pfet_01v8 ad=0.2058 pd=1.75 as=0.2058 ps=1.75 w=1.47 l=0.15
X7 w_0_0# a_200_252# a_230_420# w_0_0# sky130_fd_pr__pfet_01v8 ad=0.38955 pd=3.47 as=0.2058 ps=1.75 w=1.47 l=0.15
X8 a_230_420# a_200_252# w_0_0# w_0_0# sky130_fd_pr__pfet_01v8 ad=0.2058 pd=1.75 as=0.2058 ps=1.75 w=1.47 l=0.15
X9 a_230_420# a_200_252# w_0_0# w_0_0# sky130_fd_pr__pfet_01v8 ad=0.2058 pd=1.75 as=0.2058 ps=1.75 w=1.47 l=0.15
X10 a_230_420# a_200_252# w_0_0# w_0_0# sky130_fd_pr__pfet_01v8 ad=0.2058 pd=1.75 as=0.2058 ps=1.75 w=1.47 l=0.15
X11 w_0_0# a_200_252# a_230_420# w_0_0# sky130_fd_pr__pfet_01v8 ad=0.2058 pd=1.75 as=0.2058 ps=1.75 w=1.47 l=0.15
X12 w_0_0# a_200_252# a_230_420# w_0_0# sky130_fd_pr__pfet_01v8 ad=0.2058 pd=1.75 as=0.2058 ps=1.75 w=1.47 l=0.15
X13 w_0_0# a_200_252# a_230_420# w_0_0# sky130_fd_pr__pfet_01v8 ad=0.2058 pd=1.75 as=0.2058 ps=1.75 w=1.47 l=0.15
X14 a_230_420# a_200_252# w_0_0# w_0_0# sky130_fd_pr__pfet_01v8 ad=0.2058 pd=1.75 as=0.2058 ps=1.75 w=1.47 l=0.15
X15 a_230_420# a_200_252# w_0_0# w_0_0# sky130_fd_pr__pfet_01v8 ad=0.2058 pd=1.75 as=0.2058 ps=1.75 w=1.47 l=0.15
C0 a_230_420# a_200_252# 0.695598f
C1 a_230_420# w_0_0# 5.95388f
C2 w_0_0# a_200_252# 3.69696f
C3 a_230_420# VSUBS 0.326991f
C4 a_200_252# VSUBS 0.453817f
C5 w_0_0# VSUBS 8.09346f
.ends

.subckt TELESCOPIC_OTA_0 IB VCN VOUT VIP VIN VCP VSS VDD
XPMOS_4T_48128194_X4_Y1_1774869455_1 m1_2376_560# VCP m1_2720_1400# VDD VSS PMOS_4T_48128194_X4_Y1_1774869455
XPMOS_4T_48128194_X4_Y1_1774869455_0 VOUT VCP m1_1344_1400# VDD VSS PMOS_4T_48128194_X4_Y1_1774869455
XNMOS_4T_31167546_X10_Y1_1774869453_0 VOUT VCN m1_742_2912# VSS NMOS_4T_31167546_X10_Y1_1774869453
XNMOS_4T_31167546_X10_Y1_1774869453_1 m1_2376_560# VCN m1_3322_2912# VSS NMOS_4T_31167546_X10_Y1_1774869453
XSCM_NMOS_90644832_X6_Y1_1774869457_0 li_2985_2839# IB VSS SCM_NMOS_90644832_X6_Y1_1774869457
XNMOS_4T_47642139_X3_Y1_1774869454_0 m1_742_2912# VIN li_2985_2839# VSS NMOS_4T_47642139_X3_Y1_1774869454
XNMOS_4T_47642139_X3_Y1_1774869454_1 m1_3322_2912# VIP li_2985_2839# VSS NMOS_4T_47642139_X3_Y1_1774869454
XPMOS_S_59459431_X8_Y1_1774869456_0 m1_1344_1400# m1_2376_560# VDD VSS PMOS_S_59459431_X8_Y1_1774869456
XPMOS_S_59459431_X8_Y1_1774869456_1 m1_2720_1400# m1_2376_560# VDD VSS PMOS_S_59459431_X8_Y1_1774869456
R0 VCP.n11 VCP.t9 568.582
R1 VCP.n11 VCP.t10 568.582
R2 VCP.n12 VCP.t12 568.582
R3 VCP.n12 VCP.t14 568.582
R4 VCP.n9 VCP.t8 568.582
R5 VCP.n9 VCP.t11 568.582
R6 VCP.n7 VCP.t13 568.582
R7 VCP.n7 VCP.t15 568.582
R8 VCP.n5 VCP.t7 568.582
R9 VCP.n5 VCP.t5 568.582
R10 VCP.n3 VCP.t3 568.582
R11 VCP.n3 VCP.t0 568.582
R12 VCP.n1 VCP.t6 568.582
R13 VCP.n1 VCP.t4 568.582
R14 VCP.n0 VCP.t2 568.582
R15 VCP.n0 VCP.t1 568.582
R16 VCP.n13 VCP.n11 161.685
R17 VCP.n2 VCP.n0 161.685
R18 VCP.n13 VCP.n12 161.3
R19 VCP.n10 VCP.n9 161.3
R20 VCP.n8 VCP.n7 161.3
R21 VCP.n6 VCP.n5 161.3
R22 VCP.n4 VCP.n3 161.3
R23 VCP.n2 VCP.n1 161.3
R24 VCP.n8 VCP.n6 1.15229
R25 VCP.n4 VCP.n2 0.384429
R26 VCP.n6 VCP.n4 0.384429
R27 VCP.n10 VCP.n8 0.384429
R28 VCP VCP.n10 0.192464
R29 VCP VCP.n13 0.192464
R30 VDD.n31 VDD.n21 379.685
R31 VDD.n13 VDD.n8 379.685
R32 VDD.n39 VDD.n38 379.493
R33 VDD.n15 VDD.n14 379.3
R34 VDD.n13 VDD.n12 379.3
R35 VDD.n26 VDD.n25 379.3
R36 VDD.n36 VDD.n1 379.3
R37 VDD.n40 VDD.n39 379.3
R38 VDD.n18 VDD.n2 379.3
R39 VDD.n33 VDD.n21 379.3
R40 VDD.n37 VDD.n36 379.3
R41 VDD.n28 VDD.n27 379.3
R42 VDD.n30 VDD.n29 379.3
R43 VDD.n24 VDD.n23 200.778
R44 VDD.n25 VDD.n22 177.52
R45 VDD.n32 VDD.n1 177.52
R46 VDD.n28 VDD.n23 177.52
R47 VDD.n31 VDD.n30 162.103
R48 VDD.n9 VDD.n4 54.0349
R49 VDD.n11 VDD.n10 54.0349
R50 VDD.n7 VDD.n6 54.0349
R51 VDD.n6 VDD.n5 54.0349
R52 VDD.n27 VDD.n26 54.0349
R53 VDD.n17 VDD.n16 40.5263
R54 VDD.n34 VDD.n33 40.5263
R55 VDD.n16 VDD.n15 27.0177
R56 VDD.n15 VDD.n4 27.0177
R57 VDD.n12 VDD.n9 27.0177
R58 VDD.n12 VDD.n11 27.0177
R59 VDD.n10 VDD.n8 27.0177
R60 VDD.n8 VDD.n7 27.0177
R61 VDD.n35 VDD.n3 27.0177
R62 VDD.n20 VDD.n19 27.0177
R63 VDD.n30 VDD.n22 25.2354
R64 VDD.n32 VDD.n31 25.2354
R65 VDD.n27 VDD.n22 25.2098
R66 VDD.n33 VDD.n32 25.2098
R67 VDD.n26 VDD.n23 25.2098
R68 VDD.n41 VDD.n40 17.4775
R69 VDD.n36 VDD.n34 13.5091
R70 VDD.n36 VDD.n35 13.5091
R71 VDD.n39 VDD.n3 13.5091
R72 VDD.n39 VDD.n20 13.5091
R73 VDD.n19 VDD.n18 13.5091
R74 VDD.n18 VDD.n17 13.5091
R75 VDD.n41 VDD 13.3384
R76 VDD.n29 VDD.n0 9.68839
R77 VDD.n38 VDD.n0 9.4105
R78 VDD.n24 VDD 4.59425
R79 VDD VDD.n41 4.29113
R80 VDD VDD.n0 3.99035
R81 VDD.n37 VDD.n21 0.384429
R82 VDD.n40 VDD.n1 0.384429
R83 VDD.n40 VDD.n2 0.384429
R84 VDD.n14 VDD.n2 0.384429
R85 VDD.n14 VDD.n13 0.384429
R86 VDD.n25 VDD.n24 0.384429
R87 VDD.n29 VDD.n28 0.384429
R88 VDD.n38 VDD.n37 0.192464
R89 VCN.n29 VCN.t15 568.582
R90 VCN.n29 VCN.t9 568.582
R91 VCN.n30 VCN.t4 568.582
R92 VCN.n30 VCN.t19 568.582
R93 VCN.n32 VCN.t13 568.582
R94 VCN.n32 VCN.t14 568.582
R95 VCN.n34 VCN.t7 568.582
R96 VCN.n34 VCN.t3 568.582
R97 VCN.n36 VCN.t18 568.582
R98 VCN.n36 VCN.t12 568.582
R99 VCN.n27 VCN.t6 568.582
R100 VCN.n27 VCN.t2 568.582
R101 VCN.n25 VCN.t1 568.582
R102 VCN.n25 VCN.t17 568.582
R103 VCN.n23 VCN.t11 568.582
R104 VCN.n23 VCN.t5 568.582
R105 VCN.n21 VCN.t0 568.582
R106 VCN.n21 VCN.t16 568.582
R107 VCN.n19 VCN.t10 568.582
R108 VCN.n19 VCN.t8 568.582
R109 VCN.n17 VCN.t28 568.582
R110 VCN.n17 VCN.t30 568.582
R111 VCN.n15 VCN.t36 568.582
R112 VCN.n15 VCN.t20 568.582
R113 VCN.n13 VCN.t25 568.582
R114 VCN.n13 VCN.t31 568.582
R115 VCN.n11 VCN.t37 568.582
R116 VCN.n11 VCN.t21 568.582
R117 VCN.n9 VCN.t22 568.582
R118 VCN.n9 VCN.t26 568.582
R119 VCN.n7 VCN.t32 568.582
R120 VCN.n7 VCN.t38 568.582
R121 VCN.n5 VCN.t23 568.582
R122 VCN.n5 VCN.t27 568.582
R123 VCN.n3 VCN.t34 568.582
R124 VCN.n3 VCN.t33 568.582
R125 VCN.n1 VCN.t39 568.582
R126 VCN.n1 VCN.t24 568.582
R127 VCN.n0 VCN.t29 568.582
R128 VCN.n0 VCN.t35 568.582
R129 VCN.n31 VCN.n29 161.685
R130 VCN.n2 VCN.n0 161.685
R131 VCN.n31 VCN.n30 161.3
R132 VCN.n33 VCN.n32 161.3
R133 VCN.n35 VCN.n34 161.3
R134 VCN.n37 VCN.n36 161.3
R135 VCN.n28 VCN.n27 161.3
R136 VCN.n26 VCN.n25 161.3
R137 VCN.n24 VCN.n23 161.3
R138 VCN.n22 VCN.n21 161.3
R139 VCN.n20 VCN.n19 161.3
R140 VCN.n18 VCN.n17 161.3
R141 VCN.n16 VCN.n15 161.3
R142 VCN.n14 VCN.n13 161.3
R143 VCN.n12 VCN.n11 161.3
R144 VCN.n10 VCN.n9 161.3
R145 VCN.n8 VCN.n7 161.3
R146 VCN.n6 VCN.n5 161.3
R147 VCN.n4 VCN.n3 161.3
R148 VCN.n2 VCN.n1 161.3
R149 VCN.n20 VCN.n18 1.15229
R150 VCN.n4 VCN.n2 0.384429
R151 VCN.n6 VCN.n4 0.384429
R152 VCN.n8 VCN.n6 0.384429
R153 VCN.n10 VCN.n8 0.384429
R154 VCN.n12 VCN.n10 0.384429
R155 VCN.n14 VCN.n12 0.384429
R156 VCN.n16 VCN.n14 0.384429
R157 VCN.n18 VCN.n16 0.384429
R158 VCN.n22 VCN.n20 0.384429
R159 VCN.n24 VCN.n22 0.384429
R160 VCN.n26 VCN.n24 0.384429
R161 VCN.n28 VCN.n26 0.384429
R162 VCN.n37 VCN.n35 0.384429
R163 VCN.n35 VCN.n33 0.384429
R164 VCN.n33 VCN.n31 0.384429
R165 VCN VCN.n28 0.192464
R166 VCN VCN.n37 0.192464
R167 VSS.n31 VSS.n1 145355
R168 VSS.n11 VSS.n1 5636.21
R169 VSS.n33 VSS.n30 5142.26
R170 VSS.n28 VSS.n4 1293.47
R171 VSS.n15 VSS.n14 1179.3
R172 VSS.n8 VSS.n7 1179.3
R173 VSS.n21 VSS.n20 1179.3
R174 VSS.n22 VSS.n6 1179.3
R175 VSS.n25 VSS.n24 1179.3
R176 VSS.n23 VSS.n2 1179.3
R177 VSS.n29 VSS.n3 1179.3
R178 VSS.n10 VSS.n9 1179.3
R179 VSS.n16 VSS.n15 1179.3
R180 VSS.n18 VSS.n8 1179.3
R181 VSS.n20 VSS.n19 1179.3
R182 VSS.n6 VSS.n5 1179.3
R183 VSS.n26 VSS.n25 1179.3
R184 VSS.n27 VSS.n2 1179.3
R185 VSS.n33 VSS.n32 918.12
R186 VSS.n12 VSS.n11 879.534
R187 VSS.n28 VSS.n27 533.053
R188 VSS.n14 VSS.n13 533.053
R189 VSS.n34 VSS.n33 401.981
R190 VSS.n34 VSS.n1 401.702
R191 VSS.n13 VSS.n12 322.274
R192 VSS.n12 VSS.n9 302.719
R193 VSS.n15 VSS.n10 252.773
R194 VSS.n15 VSS.n8 252.773
R195 VSS.n20 VSS.n8 252.773
R196 VSS.n20 VSS.n6 252.773
R197 VSS.n25 VSS.n6 252.773
R198 VSS.n25 VSS.n2 252.773
R199 VSS.n32 VSS.n31 232.148
R200 VSS.n30 VSS.n2 213.094
R201 VSS.n13 VSS.n10 114.136
R202 VSS.n29 VSS.n28 114.136
R203 VSS.n30 VSS.n29 39.6799
R204 VSS.n11 VSS 21.41
R205 VSS.n17 VSS.n4 10.2762
R206 VSS.n18 VSS.n17 9.223
R207 VSS VSS.n0 4.44175
R208 VSS VSS.n0 3.95097
R209 VSS VSS.n34 3.58615
R210 VSS.n16 VSS.n9 0.384429
R211 VSS.n18 VSS.n16 0.384429
R212 VSS.n19 VSS.n18 0.384429
R213 VSS.n19 VSS.n5 0.384429
R214 VSS.n26 VSS.n5 0.384429
R215 VSS.n27 VSS.n26 0.384429
R216 VSS.n14 VSS.n7 0.384429
R217 VSS.n21 VSS.n7 0.384429
R218 VSS.n22 VSS.n21 0.384429
R219 VSS.n24 VSS.n22 0.384429
R220 VSS.n24 VSS.n23 0.384429
R221 VSS.n23 VSS.n3 0.384429
R222 VSS.n4 VSS.n3 0.384429
R223 VSS.n17 VSS.n0 0.30365
R224 IB.n12 IB.t12 568.582
R225 IB.n12 IB.t10 568.582
R226 IB.n13 IB.t32 568.582
R227 IB.n13 IB.t24 568.582
R228 IB.n15 IB.t26 568.582
R229 IB.n15 IB.t29 568.582
R230 IB.n17 IB.t4 568.582
R231 IB.n17 IB.t22 568.582
R232 IB.n19 IB.t20 568.582
R233 IB.n19 IB.t14 568.582
R234 IB.n11 IB.t30 568.582
R235 IB.n11 IB.t33 568.582
R236 IB.n9 IB.t25 568.582
R237 IB.n9 IB.t27 568.582
R238 IB.n7 IB.t6 568.582
R239 IB.n7 IB.t8 568.582
R240 IB.n5 IB.t2 568.582
R241 IB.n5 IB.t18 568.582
R242 IB.n3 IB.t28 568.582
R243 IB.n3 IB.t31 568.582
R244 IB.n1 IB.t34 568.582
R245 IB.n1 IB.t35 568.582
R246 IB.n0 IB.t0 568.582
R247 IB.n0 IB.t16 568.582
R248 IB.n29 IB.n27 175.477
R249 IB.n24 IB.n22 175.477
R250 IB.n29 IB.n28 174.326
R251 IB.n31 IB.n30 174.326
R252 IB.n26 IB.n25 174.326
R253 IB.n24 IB.n23 174.326
R254 IB.n14 IB.n12 161.685
R255 IB.n2 IB.n0 161.685
R256 IB.n14 IB.n13 161.3
R257 IB.n16 IB.n15 161.3
R258 IB.n18 IB.n17 161.3
R259 IB.n20 IB.n19 161.3
R260 IB.n21 IB.n11 161.3
R261 IB.n10 IB.n9 161.3
R262 IB.n8 IB.n7 161.3
R263 IB.n6 IB.n5 161.3
R264 IB.n4 IB.n3 161.3
R265 IB.n2 IB.n1 161.3
R266 IB.n27 IB.t11 11.4291
R267 IB.n27 IB.t13 11.4291
R268 IB.n28 IB.t23 11.4291
R269 IB.n28 IB.t5 11.4291
R270 IB.n30 IB.t15 11.4291
R271 IB.n30 IB.t21 11.4291
R272 IB.n25 IB.t9 11.4291
R273 IB.n25 IB.t7 11.4291
R274 IB.n23 IB.t19 11.4291
R275 IB.n23 IB.t3 11.4291
R276 IB.n22 IB.t17 11.4291
R277 IB.n22 IB.t1 11.4291
R278 IB IB.n21 5.438
R279 IB IB.n32 5.438
R280 IB.n32 IB.n26 0.768357
R281 IB.n4 IB.n2 0.384429
R282 IB.n6 IB.n4 0.384429
R283 IB.n8 IB.n6 0.384429
R284 IB.n10 IB.n8 0.384429
R285 IB.n21 IB.n10 0.384429
R286 IB.n21 IB.n20 0.384429
R287 IB.n20 IB.n18 0.384429
R288 IB.n18 IB.n16 0.384429
R289 IB.n16 IB.n14 0.384429
R290 IB.n26 IB.n24 0.384429
R291 IB.n32 IB.n31 0.384429
R292 IB.n31 IB.n29 0.384429
R293 VIN.n2 VIN.t1 568.582
R294 VIN.n2 VIN.t4 568.582
R295 VIN.n1 VIN.t5 568.582
R296 VIN.n1 VIN.t0 568.582
R297 VIN.n0 VIN.t2 568.582
R298 VIN.n0 VIN.t3 568.582
R299 VIN VIN.n2 161.685
R300 VIN VIN.n0 161.685
R301 VIN VIN.n1 161.3
R302 VIP.n2 VIP.t3 568.582
R303 VIP.n2 VIP.t2 568.582
R304 VIP.n1 VIP.t0 568.582
R305 VIP.n1 VIP.t5 568.582
R306 VIP.n0 VIP.t4 568.582
R307 VIP.n0 VIP.t1 568.582
R308 VIP VIP.n2 161.685
R309 VIP VIP.n0 161.685
R310 VIP VIP.n1 161.3
C0 m1_1344_1400# m1_2720_1400# 0.069026f
C1 VCN m1_2376_560# 7.6e-20
C2 VCN m1_2720_1400# 8.9e-22
C3 IB li_2985_2839# 0.082446f
C4 VCP VIN 0.005097f
C5 m1_1344_1400# VDD 0.241072f
C6 VCP VIP 0.005097f
C7 VCN VDD 0.474566f
C8 m1_1344_1400# m1_742_2912# 0.007696f
C9 m1_3322_2912# VIP 0.001115f
C10 VCP VOUT 0.112538f
C11 VCN m1_742_2912# 0.013173f
C12 VOUT m1_3322_2912# 2.28e-19
C13 m1_2376_560# VIN 0.003767f
C14 VIN m1_2720_1400# 9.6e-20
C15 VCP li_2985_2839# 0.06807f
C16 m1_2376_560# VIP 0.012199f
C17 m1_2720_1400# VIP 0.017018f
C18 m1_3322_2912# li_2985_2839# 0.084541f
C19 VCN m1_1344_1400# 8.9e-22
C20 m1_2376_560# VOUT 0.069445f
C21 VDD VIN 0.072512f
C22 IB m1_3322_2912# 8.9e-22
C23 VOUT m1_2720_1400# 0.001506f
C24 m1_742_2912# VIN 0.001115f
C25 VDD VIP 0.05144f
C26 m1_2376_560# li_2985_2839# 0.566348f
C27 m1_2720_1400# li_2985_2839# 0.018882f
C28 VOUT VDD 0.682721f
C29 VOUT m1_742_2912# 0.206147f
C30 m1_1344_1400# VIN 0.017018f
C31 VDD li_2985_2839# 1.165525f
C32 VCN VIN 0.005714f
C33 VCP m1_3322_2912# 0.00156f
C34 IB VDD 0.063455f
C35 m1_1344_1400# VIP 9.6e-20
C36 m1_742_2912# li_2985_2839# 0.401781f
C37 VCN VIP 0.005714f
C38 IB m1_742_2912# 1.89e-19
C39 m1_1344_1400# VOUT 0.413323f
C40 VCN VOUT 6.46e-19
C41 VCP m1_2376_560# 0.154751f
C42 VCP m1_2720_1400# 0.013113f
C43 m1_1344_1400# li_2985_2839# 0.01714f
C44 m1_2376_560# m1_3322_2912# 0.238946f
C45 m1_3322_2912# m1_2720_1400# 0.007765f
C46 VCN li_2985_2839# 0.180162f
C47 VCN IB 0.044777f
C48 VCP VDD 0.216227f
C49 m1_3322_2912# VDD 0.364346f
C50 VCP m1_742_2912# 0.00156f
C51 m1_2376_560# m1_2720_1400# 0.509293f
C52 VOUT VIN 0.017028f
C53 m1_3322_2912# m1_742_2912# 0.063575f
C54 VOUT VIP 5.51e-20
C55 VIN li_2985_2839# 2.35e-20
C56 m1_2376_560# VDD 1.398211f
C57 VDD m1_2720_1400# 0.199806f
C58 VCP m1_1344_1400# 0.013113f
C59 m1_2376_560# m1_742_2912# 2.35e-19
C60 VCN VCP 0.014618f
C61 VCN m1_3322_2912# 0.013173f
C62 VOUT li_2985_2839# 0.794856f
C63 IB VOUT 0.001135f
C64 VDD m1_742_2912# 0.414144f
C65 m1_1344_1400# m1_2376_560# 0.034428f
C66 VCP VSS 0.603272f
C67 VOUT VSS 11.179742f
C68 VCN VSS 8.248108f
C69 VDD.n0 VSS 1.45114f
C70 VDD.n1 VSS 0.087791f
C71 VDD.n2 VSS 0.031236f
C72 VDD.n3 VSS 0.386342f
C73 VDD.n4 VSS 0.193171f
C74 VDD.n5 VSS 0.257561f
C75 VDD.n6 VSS 0.257561f
C76 VDD.n7 VSS 0.193171f
C77 VDD.n8 VSS 0.121569f
C78 VDD.n9 VSS 0.193171f
C79 VDD.n10 VSS 0.193171f
C80 VDD.n11 VSS 0.193171f
C81 VDD.n12 VSS 0.121543f
C82 VDD.n13 VSS 0.056678f
C83 VDD.n14 VSS 0.031236f
C84 VDD.n15 VSS 0.121543f
C85 VDD.n16 VSS 0.193171f
C86 VDD.n17 VSS 0.386342f
C87 VDD.n18 VSS 0.250324f
C88 VDD.n19 VSS 0.386342f
C89 VDD.n20 VSS 0.386342f
C90 VDD.n21 VSS 0.056678f
C91 VDD.n22 VSS 1.23e-19
C92 VDD.n23 VSS 2.70358f
C93 VDD.n24 VSS 1.54934f
C94 VDD.n25 VSS 0.087791f
C95 VDD.n26 VSS 1.01577f
C96 VDD.n27 VSS 1.01577f
C97 VDD.n28 VSS 0.087791f
C98 VDD.n29 VSS 0.084521f
C99 VDD.n30 VSS 2.04604f
C100 VDD.n31 VSS 2.04607f
C101 VDD.n32 VSS 1.23e-19
C102 VDD.n33 VSS 0.88699f
C103 VDD.n34 VSS 0.515122f
C104 VDD.n35 VSS 0.386342f
C105 VDD.n36 VSS 0.243087f
C106 VDD.n37 VSS 0.026466f
C107 VDD.n38 VSS 0.066519f
C108 VDD.n39 VSS 0.243097f
C109 VDD.n40 VSS 0.952915f
C110 VDD.n41 VSS 1.75586f
C111 VCP.t1 VSS 0.040138f
C112 VCP.t2 VSS 0.040138f
C113 VCP.n0 VSS 0.132899f
C114 VCP.t4 VSS 0.040138f
C115 VCP.t6 VSS 0.040138f
C116 VCP.n1 VSS 0.132576f
C117 VCP.n2 VSS 0.296383f
C118 VCP.t0 VSS 0.040138f
C119 VCP.t3 VSS 0.040138f
C120 VCP.n3 VSS 0.132576f
C121 VCP.n4 VSS 0.160561f
C122 VCP.t5 VSS 0.040138f
C123 VCP.t7 VSS 0.040138f
C124 VCP.n5 VSS 0.132576f
C125 VCP.n6 VSS 0.241321f
C126 VCP.t15 VSS 0.040138f
C127 VCP.t13 VSS 0.040138f
C128 VCP.n7 VSS 0.132576f
C129 VCP.n8 VSS 0.241321f
C130 VCP.t11 VSS 0.040138f
C131 VCP.t8 VSS 0.040138f
C132 VCP.n9 VSS 0.132576f
C133 VCP.n10 VSS 0.140371f
C134 VCP.t10 VSS 0.040138f
C135 VCP.t9 VSS 0.040138f
C136 VCP.n11 VSS 0.132899f
C137 VCP.t14 VSS 0.040138f
C138 VCP.t12 VSS 0.040138f
C139 VCP.n12 VSS 0.132576f
C140 VCP.n13 VSS 0.276193f
C141 m1_2376_560# VSS 1.888336f
C142 m1_3322_2912# VSS 1.002053f
C143 VIP VSS 1.349771f
C144 m1_742_2912# VSS 0.944637f
C145 li_2985_2839# VSS 6.618479f
C146 VIN VSS 1.341933f
C147 IB VSS 11.713118f
C148 m1_1344_1400# VSS 0.460633f
C149 VDD VSS 34.94031f
C150 m1_2720_1400# VSS 0.519636f
.ends
