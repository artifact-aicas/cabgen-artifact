* NGSPICE file created from TELESCOPIC_OTA_0.ext - technology: sky130A

.subckt PMOS_4T_48128194_X4_Y1_1774869455 a_230_420# a_200_252# a_147_420# w_0_0#
X0 a_230_420# a_200_252# a_147_420# w_0_0# sky130_fd_pr__pfet_01v8 ad=0.2058 pd=1.75 as=0.2058 ps=1.75 w=1.47 l=0.15 M=8
.ends

.subckt NMOS_4T_31167546_X10_Y1_1774869453 a_230_420# a_200_252# a_147_420# a_241_1232#
X0 a_147_420# a_200_252# a_230_420# a_241_1232# sky130_fd_pr__nfet_01v8 ad=0.2058 pd=1.75 as=0.2058 ps=1.75 w=1.47 l=0.15 M=20
.ends

.subckt SCM_NMOS_90644832_X6_Y1_1774869457 a_402_420# a_200_252# a_147_420#
X0 a_147_420# a_200_252# a_402_420# a_147_420# sky130_fd_pr__nfet_01v8 ad=0.2058 pd=1.75 as=0.2058 ps=1.75 w=1.47 l=0.15 M=12
X1 a_147_420# a_200_252# a_200_252# a_147_420# sky130_fd_pr__nfet_01v8 ad=0.2058 pd=1.75 as=0.2058 ps=1.75 w=1.47 l=0.15 M=12
.ends

.subckt NMOS_4T_47642139_X3_Y1_1774869454 a_230_420# a_200_252# a_147_420# a_241_1232#
X0 a_147_420# a_200_252# a_230_420# a_241_1232# sky130_fd_pr__nfet_01v8 ad=0.2058 pd=1.75 as=0.2058 ps=1.75 w=1.47 l=0.15 M=6
.ends

.subckt PMOS_S_59459431_X8_Y1_1774869456 a_230_420# a_200_252# w_0_0#
X0 a_230_420# a_200_252# w_0_0# w_0_0# sky130_fd_pr__pfet_01v8 ad=0.2058 pd=1.75 as=0.2058 ps=1.75 w=1.47 l=0.15 M=16
.ends

.subckt TELESCOPIC_OTA_0 IB VCN VOUT VIP VIN VCP VSS VDD
XPMOS_4T_48128194_X4_Y1_1774869455_1 m1_2376_560# VCP m1_2720_1400# VDD PMOS_4T_48128194_X4_Y1_1774869455
XPMOS_4T_48128194_X4_Y1_1774869455_0 VOUT VCP m1_1344_1400# VDD PMOS_4T_48128194_X4_Y1_1774869455
XNMOS_4T_31167546_X10_Y1_1774869453_0 VOUT VCN m1_742_2912# VSS NMOS_4T_31167546_X10_Y1_1774869453
XNMOS_4T_31167546_X10_Y1_1774869453_1 m1_2376_560# VCN m1_3322_2912# VSS NMOS_4T_31167546_X10_Y1_1774869453
XSCM_NMOS_90644832_X6_Y1_1774869457_0 li_2985_2839# IB VSS SCM_NMOS_90644832_X6_Y1_1774869457
XNMOS_4T_47642139_X3_Y1_1774869454_0 m1_742_2912# VIN li_2985_2839# VSS NMOS_4T_47642139_X3_Y1_1774869454
XNMOS_4T_47642139_X3_Y1_1774869454_1 m1_3322_2912# VIP li_2985_2839# VSS NMOS_4T_47642139_X3_Y1_1774869454
XPMOS_S_59459431_X8_Y1_1774869456_0 m1_1344_1400# m1_2376_560# VDD PMOS_S_59459431_X8_Y1_1774869456
XPMOS_S_59459431_X8_Y1_1774869456_1 m1_2720_1400# m1_2376_560# VDD PMOS_S_59459431_X8_Y1_1774869456
.ends
