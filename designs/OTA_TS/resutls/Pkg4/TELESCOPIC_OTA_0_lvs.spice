* NGSPICE file created from TELESCOPIC_OTA_0.ext - technology: sky130A

.subckt PMOS_S_86315193_X6_Y1_1774869361 a_230_441# a_200_252# w_0_0#
X0 w_0_0# a_200_252# a_230_441# w_0_0# sky130_fd_pr__pfet_01v8 ad=0.1764 pd=1.54 as=0.1764 ps=1.54 w=1.26 l=0.15 M=12
.ends

.subckt NMOS_4T_67607497_X1_Y1_1774869359 a_230_441# a_200_252# a_147_441# a_241_1232#
X0 a_230_441# a_200_252# a_147_441# a_241_1232# sky130_fd_pr__nfet_01v8 ad=0.1764 pd=1.54 as=0.3339 ps=3.05 w=1.26 l=0.15 M=2
.ends

.subckt SCM_NMOS_71172734_X5_Y1_1774869362 a_402_441# a_200_252# a_147_441#
X0 a_147_441# a_200_252# a_200_252# a_147_441# sky130_fd_pr__nfet_01v8 ad=0.1764 pd=1.54 as=0.1764 ps=1.54 w=1.26 l=0.15 M=10
X1 a_402_441# a_200_252# a_147_441# a_147_441# sky130_fd_pr__nfet_01v8 ad=0.1764 pd=1.54 as=0.1764 ps=1.54 w=1.26 l=0.15 M=10
.ends

.subckt PMOS_4T_36899923_X2_Y1_1774869360 a_230_441# a_200_252# a_147_441# w_0_0#
X0 a_147_441# a_200_252# a_230_441# w_0_0# sky130_fd_pr__pfet_01v8 ad=0.1764 pd=1.54 as=0.1764 ps=1.54 w=1.26 l=0.15 M=4
.ends

.subckt NMOS_4T_35702222_X7_Y1_1774869358 a_230_441# a_200_252# a_147_441# a_241_1232#
X0 a_147_441# a_200_252# a_230_441# a_241_1232# sky130_fd_pr__nfet_01v8 ad=0.1764 pd=1.54 as=0.1764 ps=1.54 w=1.26 l=0.15 M=14
.ends

.subckt TELESCOPIC_OTA_0 IB VCN VOUT VIP VIN VCP VSS VDD
XPMOS_S_86315193_X6_Y1_1774869361_0 m1_1000_1400# m1_1290_560# VDD PMOS_S_86315193_X6_Y1_1774869361
XNMOS_4T_67607497_X1_Y1_1774869359_0 m1_656_2912# VIN li_921_2839# VSS NMOS_4T_67607497_X1_Y1_1774869359
XSCM_NMOS_71172734_X5_Y1_1774869362_0 li_921_2839# IB VSS SCM_NMOS_71172734_X5_Y1_1774869362
XPMOS_S_86315193_X6_Y1_1774869361_1 m1_2032_1400# m1_1290_560# VDD PMOS_S_86315193_X6_Y1_1774869361
XNMOS_4T_67607497_X1_Y1_1774869359_1 m1_2290_2912# VIP li_921_2839# VSS NMOS_4T_67607497_X1_Y1_1774869359
XPMOS_4T_36899923_X2_Y1_1774869360_0 VOUT VCP m1_1000_1400# VDD PMOS_4T_36899923_X2_Y1_1774869360
XPMOS_4T_36899923_X2_Y1_1774869360_1 m1_1290_560# VCP m1_2032_1400# VDD PMOS_4T_36899923_X2_Y1_1774869360
XNMOS_4T_35702222_X7_Y1_1774869358_0 VOUT VCN m1_656_2912# VSS NMOS_4T_35702222_X7_Y1_1774869358
XNMOS_4T_35702222_X7_Y1_1774869358_1 m1_1290_560# VCN m1_2290_2912# VSS NMOS_4T_35702222_X7_Y1_1774869358
.ends
