* NGSPICE file created from TELESCOPIC_OTA_0.ext - technology: sky130A

.subckt PMOS_S_86315193_X6_Y1_1774869361 a_230_441# a_200_252# w_0_0# VSUBS
X0 w_0_0# a_200_252# a_230_441# w_0_0# sky130_fd_pr__pfet_01v8 ad=0.1764 pd=1.54 as=0.1764 ps=1.54 w=1.26 l=0.15
X1 w_0_0# a_200_252# a_230_441# w_0_0# sky130_fd_pr__pfet_01v8 ad=0.1764 pd=1.54 as=0.1764 ps=1.54 w=1.26 l=0.15
X2 a_230_441# a_200_252# w_0_0# w_0_0# sky130_fd_pr__pfet_01v8 ad=0.1764 pd=1.54 as=0.1764 ps=1.54 w=1.26 l=0.15
X3 a_230_441# a_200_252# w_0_0# w_0_0# sky130_fd_pr__pfet_01v8 ad=0.1764 pd=1.54 as=0.1764 ps=1.54 w=1.26 l=0.15
X4 a_230_441# a_200_252# w_0_0# w_0_0# sky130_fd_pr__pfet_01v8 ad=0.1764 pd=1.54 as=0.1764 ps=1.54 w=1.26 l=0.15
X5 w_0_0# a_200_252# a_230_441# w_0_0# sky130_fd_pr__pfet_01v8 ad=0.3339 pd=3.05 as=0.1764 ps=1.54 w=1.26 l=0.15
X6 w_0_0# a_200_252# a_230_441# w_0_0# sky130_fd_pr__pfet_01v8 ad=0.1764 pd=1.54 as=0.1764 ps=1.54 w=1.26 l=0.15
X7 w_0_0# a_200_252# a_230_441# w_0_0# sky130_fd_pr__pfet_01v8 ad=0.1764 pd=1.54 as=0.1764 ps=1.54 w=1.26 l=0.15
X8 a_230_441# a_200_252# w_0_0# w_0_0# sky130_fd_pr__pfet_01v8 ad=0.1764 pd=1.54 as=0.1764 ps=1.54 w=1.26 l=0.15
X9 a_230_441# a_200_252# w_0_0# w_0_0# sky130_fd_pr__pfet_01v8 ad=0.1764 pd=1.54 as=0.1764 ps=1.54 w=1.26 l=0.15
X10 w_0_0# a_200_252# a_230_441# w_0_0# sky130_fd_pr__pfet_01v8 ad=0.1764 pd=1.54 as=0.1764 ps=1.54 w=1.26 l=0.15
X11 a_230_441# a_200_252# w_0_0# w_0_0# sky130_fd_pr__pfet_01v8 ad=0.1764 pd=1.54 as=0.3339 ps=3.05 w=1.26 l=0.15
C0 w_0_0# a_230_441# 4.47515f
C1 w_0_0# a_200_252# 2.98076f
C2 a_200_252# a_230_441# 0.538779f
C3 a_230_441# VSUBS 0.244237f
C4 a_200_252# VSUBS 0.377589f
C5 w_0_0# VSUBS 6.60734f
.ends

.subckt NMOS_4T_67607497_X1_Y1_1774869359 a_230_441# a_200_252# a_147_441# a_241_1232#
X0 a_230_441# a_200_252# a_147_441# a_241_1232# sky130_fd_pr__nfet_01v8 ad=0.1764 pd=1.54 as=0.3339 ps=3.05 w=1.26 l=0.15
X1 a_147_441# a_200_252# a_230_441# a_241_1232# sky130_fd_pr__nfet_01v8 ad=0.3339 pd=3.05 as=0.1764 ps=1.54 w=1.26 l=0.15
C0 a_200_252# a_230_441# 0.094197f
C1 a_200_252# a_147_441# 0.090431f
C2 a_147_441# a_230_441# 0.701359f
C3 a_230_441# a_241_1232# 0.129506f
C4 a_147_441# a_241_1232# 0.427827f
C5 a_200_252# a_241_1232# 0.687344f
.ends

.subckt SCM_NMOS_71172734_X5_Y1_1774869362 a_402_441# a_200_252# a_147_441#
X0 a_147_441# a_200_252# a_200_252# a_147_441# sky130_fd_pr__nfet_01v8 ad=0.1764 pd=1.54 as=0.1764 ps=1.54 w=1.26 l=0.15
X1 a_147_441# a_200_252# a_200_252# a_147_441# sky130_fd_pr__nfet_01v8 ad=0.1764 pd=1.54 as=0.1764 ps=1.54 w=1.26 l=0.15
X2 a_200_252# a_200_252# a_147_441# a_147_441# sky130_fd_pr__nfet_01v8 ad=0.1764 pd=1.54 as=0.3339 ps=3.05 w=1.26 l=0.15
X3 a_402_441# a_200_252# a_147_441# a_147_441# sky130_fd_pr__nfet_01v8 ad=0.1764 pd=1.54 as=0.1764 ps=1.54 w=1.26 l=0.15
X4 a_147_441# a_200_252# a_200_252# a_147_441# sky130_fd_pr__nfet_01v8 ad=0.1764 pd=1.54 as=0.1764 ps=1.54 w=1.26 l=0.15
X5 a_147_441# a_200_252# a_200_252# a_147_441# sky130_fd_pr__nfet_01v8 ad=0.1764 pd=1.54 as=0.1764 ps=1.54 w=1.26 l=0.15
X6 a_402_441# a_200_252# a_147_441# a_147_441# sky130_fd_pr__nfet_01v8 ad=0.1764 pd=1.54 as=0.1764 ps=1.54 w=1.26 l=0.15
X7 a_402_441# a_200_252# a_147_441# a_147_441# sky130_fd_pr__nfet_01v8 ad=0.1764 pd=1.54 as=0.1764 ps=1.54 w=1.26 l=0.15
X8 a_147_441# a_200_252# a_402_441# a_147_441# sky130_fd_pr__nfet_01v8 ad=0.1764 pd=1.54 as=0.1764 ps=1.54 w=1.26 l=0.15
X9 a_147_441# a_200_252# a_402_441# a_147_441# sky130_fd_pr__nfet_01v8 ad=0.3339 pd=3.05 as=0.1764 ps=1.54 w=1.26 l=0.15
X10 a_402_441# a_200_252# a_147_441# a_147_441# sky130_fd_pr__nfet_01v8 ad=0.1764 pd=1.54 as=0.1764 ps=1.54 w=1.26 l=0.15
X11 a_402_441# a_200_252# a_147_441# a_147_441# sky130_fd_pr__nfet_01v8 ad=0.1764 pd=1.54 as=0.1764 ps=1.54 w=1.26 l=0.15
X12 a_147_441# a_200_252# a_402_441# a_147_441# sky130_fd_pr__nfet_01v8 ad=0.1764 pd=1.54 as=0.1764 ps=1.54 w=1.26 l=0.15
X13 a_200_252# a_200_252# a_147_441# a_147_441# sky130_fd_pr__nfet_01v8 ad=0.1764 pd=1.54 as=0.1764 ps=1.54 w=1.26 l=0.15
X14 a_147_441# a_200_252# a_402_441# a_147_441# sky130_fd_pr__nfet_01v8 ad=0.1764 pd=1.54 as=0.1764 ps=1.54 w=1.26 l=0.15
X15 a_147_441# a_200_252# a_402_441# a_147_441# sky130_fd_pr__nfet_01v8 ad=0.1764 pd=1.54 as=0.1764 ps=1.54 w=1.26 l=0.15
X16 a_200_252# a_200_252# a_147_441# a_147_441# sky130_fd_pr__nfet_01v8 ad=0.1764 pd=1.54 as=0.1764 ps=1.54 w=1.26 l=0.15
X17 a_200_252# a_200_252# a_147_441# a_147_441# sky130_fd_pr__nfet_01v8 ad=0.1764 pd=1.54 as=0.1764 ps=1.54 w=1.26 l=0.15
X18 a_147_441# a_200_252# a_200_252# a_147_441# sky130_fd_pr__nfet_01v8 ad=0.1764 pd=1.54 as=0.1764 ps=1.54 w=1.26 l=0.15
X19 a_200_252# a_200_252# a_147_441# a_147_441# sky130_fd_pr__nfet_01v8 ad=0.1764 pd=1.54 as=0.1764 ps=1.54 w=1.26 l=0.15
C0 a_200_252# a_402_441# 1.37178f
C1 a_402_441# a_147_441# 4.27581f
C2 a_200_252# a_147_441# 9.51295f
.ends

.subckt PMOS_4T_36899923_X2_Y1_1774869360 a_230_441# a_200_252# a_147_441# w_0_0#
+ VSUBS
X0 a_147_441# a_200_252# a_230_441# w_0_0# sky130_fd_pr__pfet_01v8 ad=0.1764 pd=1.54 as=0.1764 ps=1.54 w=1.26 l=0.15
X1 a_230_441# a_200_252# a_147_441# w_0_0# sky130_fd_pr__pfet_01v8 ad=0.1764 pd=1.54 as=0.1764 ps=1.54 w=1.26 l=0.15
X2 a_147_441# a_200_252# a_230_441# w_0_0# sky130_fd_pr__pfet_01v8 ad=0.3339 pd=3.05 as=0.1764 ps=1.54 w=1.26 l=0.15
X3 a_230_441# a_200_252# a_147_441# w_0_0# sky130_fd_pr__pfet_01v8 ad=0.1764 pd=1.54 as=0.3339 ps=3.05 w=1.26 l=0.15
C0 a_230_441# w_0_0# 0.076817f
C1 a_230_441# a_147_441# 1.3461f
C2 a_230_441# a_200_252# 0.17932f
C3 w_0_0# a_147_441# 0.229025f
C4 w_0_0# a_200_252# 0.827115f
C5 a_200_252# a_147_441# 0.171288f
C6 a_230_441# VSUBS 0.078728f
C7 a_147_441# VSUBS 0.273523f
C8 a_200_252# VSUBS 0.212118f
C9 w_0_0# VSUBS 3.22536f
.ends

.subckt NMOS_4T_35702222_X7_Y1_1774869358 a_230_441# a_200_252# a_147_441# a_241_1232#
X0 a_147_441# a_200_252# a_230_441# a_241_1232# sky130_fd_pr__nfet_01v8 ad=0.1764 pd=1.54 as=0.1764 ps=1.54 w=1.26 l=0.15
X1 a_147_441# a_200_252# a_230_441# a_241_1232# sky130_fd_pr__nfet_01v8 ad=0.3339 pd=3.05 as=0.1764 ps=1.54 w=1.26 l=0.15
X2 a_230_441# a_200_252# a_147_441# a_241_1232# sky130_fd_pr__nfet_01v8 ad=0.1764 pd=1.54 as=0.3339 ps=3.05 w=1.26 l=0.15
X3 a_147_441# a_200_252# a_230_441# a_241_1232# sky130_fd_pr__nfet_01v8 ad=0.1764 pd=1.54 as=0.1764 ps=1.54 w=1.26 l=0.15
X4 a_147_441# a_200_252# a_230_441# a_241_1232# sky130_fd_pr__nfet_01v8 ad=0.1764 pd=1.54 as=0.1764 ps=1.54 w=1.26 l=0.15
X5 a_230_441# a_200_252# a_147_441# a_241_1232# sky130_fd_pr__nfet_01v8 ad=0.1764 pd=1.54 as=0.1764 ps=1.54 w=1.26 l=0.15
X6 a_230_441# a_200_252# a_147_441# a_241_1232# sky130_fd_pr__nfet_01v8 ad=0.1764 pd=1.54 as=0.1764 ps=1.54 w=1.26 l=0.15
X7 a_230_441# a_200_252# a_147_441# a_241_1232# sky130_fd_pr__nfet_01v8 ad=0.1764 pd=1.54 as=0.1764 ps=1.54 w=1.26 l=0.15
X8 a_147_441# a_200_252# a_230_441# a_241_1232# sky130_fd_pr__nfet_01v8 ad=0.1764 pd=1.54 as=0.1764 ps=1.54 w=1.26 l=0.15
X9 a_147_441# a_200_252# a_230_441# a_241_1232# sky130_fd_pr__nfet_01v8 ad=0.1764 pd=1.54 as=0.1764 ps=1.54 w=1.26 l=0.15
X10 a_147_441# a_200_252# a_230_441# a_241_1232# sky130_fd_pr__nfet_01v8 ad=0.1764 pd=1.54 as=0.1764 ps=1.54 w=1.26 l=0.15
X11 a_230_441# a_200_252# a_147_441# a_241_1232# sky130_fd_pr__nfet_01v8 ad=0.1764 pd=1.54 as=0.1764 ps=1.54 w=1.26 l=0.15
X12 a_230_441# a_200_252# a_147_441# a_241_1232# sky130_fd_pr__nfet_01v8 ad=0.1764 pd=1.54 as=0.1764 ps=1.54 w=1.26 l=0.15
X13 a_230_441# a_200_252# a_147_441# a_241_1232# sky130_fd_pr__nfet_01v8 ad=0.1764 pd=1.54 as=0.1764 ps=1.54 w=1.26 l=0.15
C0 a_200_252# a_230_441# 0.628643f
C1 a_200_252# a_147_441# 0.629151f
C2 a_147_441# a_230_441# 4.87258f
C3 a_230_441# a_241_1232# 0.551041f
C4 a_147_441# a_241_1232# 0.769405f
C5 a_200_252# a_241_1232# 3.08276f
.ends

.subckt TELESCOPIC_OTA_0 IB VCN VOUT VIP VIN VCP VSS VDD
XPMOS_S_86315193_X6_Y1_1774869361_0 m1_1000_1400# m1_1290_560# VDD VSS PMOS_S_86315193_X6_Y1_1774869361
XNMOS_4T_67607497_X1_Y1_1774869359_0 m1_656_2912# VIN li_921_2839# VSS NMOS_4T_67607497_X1_Y1_1774869359
XSCM_NMOS_71172734_X5_Y1_1774869362_0 li_921_2839# IB VSS SCM_NMOS_71172734_X5_Y1_1774869362
XPMOS_S_86315193_X6_Y1_1774869361_1 m1_2032_1400# m1_1290_560# VDD VSS PMOS_S_86315193_X6_Y1_1774869361
XNMOS_4T_67607497_X1_Y1_1774869359_1 m1_2290_2912# VIP li_921_2839# VSS NMOS_4T_67607497_X1_Y1_1774869359
XPMOS_4T_36899923_X2_Y1_1774869360_0 VOUT VCP m1_1000_1400# VDD VSS PMOS_4T_36899923_X2_Y1_1774869360
XPMOS_4T_36899923_X2_Y1_1774869360_1 m1_1290_560# VCP m1_2032_1400# VDD VSS PMOS_4T_36899923_X2_Y1_1774869360
XNMOS_4T_35702222_X7_Y1_1774869358_0 VOUT VCN m1_656_2912# VSS NMOS_4T_35702222_X7_Y1_1774869358
XNMOS_4T_35702222_X7_Y1_1774869358_1 m1_1290_560# VCN m1_2290_2912# VSS NMOS_4T_35702222_X7_Y1_1774869358
R0 VDD VDD.n0 1031.48
R1 VDD.n5 VDD.n4 379.685
R2 VDD.n15 VDD.n2 379.685
R3 VDD.n6 VDD.n5 379.3
R4 VDD.n9 VDD.n1 379.3
R5 VDD.n22 VDD.n21 379.3
R6 VDD.n18 VDD.n2 379.3
R7 VDD VDD.n0 323.442
R8 VDD.n4 VDD.n0 162.103
R9 VDD.n4 VDD.n3 81.0521
R10 VDD.n8 VDD.n7 54.0349
R11 VDD.n11 VDD.n10 54.0349
R12 VDD.n20 VDD.n19 54.0349
R13 VDD.n17 VDD.n16 54.0349
R14 VDD.n14 VDD.n13 54.0349
R15 VDD.n13 VDD.n12 54.0349
R16 VDD.n6 VDD.n3 27.0177
R17 VDD.n7 VDD.n6 27.0177
R18 VDD.n9 VDD.n8 27.0177
R19 VDD.n10 VDD.n9 27.0177
R20 VDD.n21 VDD.n11 27.0177
R21 VDD.n21 VDD.n20 27.0177
R22 VDD.n19 VDD.n18 27.0177
R23 VDD.n18 VDD.n17 27.0177
R24 VDD.n16 VDD.n15 27.0177
R25 VDD.n15 VDD.n14 27.0177
R26 VDD.n23 VDD.n22 17.4775
R27 VDD.n23 VDD 13.3384
R28 VDD VDD.n23 4.13956
R29 VDD.n5 VDD.n1 0.384429
R30 VDD.n22 VDD.n1 0.384429
R31 VDD.n22 VDD.n2 0.384429
R32 VIN.n0 VIN.t0 568.582
R33 VIN.n0 VIN.t1 568.582
R34 VIN VIN.n0 161.493
R35 IB.n10 IB.t14 568.582
R36 IB.n10 IB.t12 568.582
R37 IB.n11 IB.t25 568.582
R38 IB.n11 IB.t28 568.582
R39 IB.n13 IB.t0 568.582
R40 IB.n13 IB.t10 568.582
R41 IB.n15 IB.t26 568.582
R42 IB.n15 IB.t29 568.582
R43 IB.n9 IB.t6 568.582
R44 IB.n9 IB.t18 568.582
R45 IB.n7 IB.t21 568.582
R46 IB.n7 IB.t27 568.582
R47 IB.n5 IB.t4 568.582
R48 IB.n5 IB.t16 568.582
R49 IB.n3 IB.t22 568.582
R50 IB.n3 IB.t23 568.582
R51 IB.n1 IB.t8 568.582
R52 IB.n1 IB.t2 568.582
R53 IB.n0 IB.t20 568.582
R54 IB.n0 IB.t24 568.582
R55 IB.n24 IB.n22 180.47
R56 IB.n20 IB.n18 180.47
R57 IB.n24 IB.n23 179.702
R58 IB.n25 IB.n21 179.702
R59 IB.n20 IB.n19 179.702
R60 IB.n12 IB.n10 161.685
R61 IB.n2 IB.n0 161.685
R62 IB.n12 IB.n11 161.3
R63 IB.n14 IB.n13 161.3
R64 IB.n16 IB.n15 161.3
R65 IB.n17 IB.n9 161.3
R66 IB.n8 IB.n7 161.3
R67 IB.n6 IB.n5 161.3
R68 IB.n4 IB.n3 161.3
R69 IB.n2 IB.n1 161.3
R70 IB.n22 IB.t13 13.3338
R71 IB.n22 IB.t15 13.3338
R72 IB.n23 IB.t11 13.3338
R73 IB.n23 IB.t1 13.3338
R74 IB.n21 IB.t19 13.3338
R75 IB.n21 IB.t7 13.3338
R76 IB.n19 IB.t17 13.3338
R77 IB.n19 IB.t5 13.3338
R78 IB.n18 IB.t3 13.3338
R79 IB.n18 IB.t9 13.3338
R80 IB IB.n17 5.438
R81 IB IB.n25 5.438
R82 IB.n25 IB.n20 0.768357
R83 IB.n25 IB.n24 0.768357
R84 IB.n4 IB.n2 0.384429
R85 IB.n6 IB.n4 0.384429
R86 IB.n8 IB.n6 0.384429
R87 IB.n17 IB.n8 0.384429
R88 IB.n17 IB.n16 0.384429
R89 IB.n16 IB.n14 0.384429
R90 IB.n14 IB.n12 0.384429
R91 VIP.n0 VIP.t1 568.582
R92 VIP.n0 VIP.t0 568.582
R93 VIP VIP.n0 161.493
R94 VCP.n5 VCP.t2 568.582
R95 VCP.n5 VCP.t1 568.582
R96 VCP.n3 VCP.t0 568.582
R97 VCP.n3 VCP.t3 568.582
R98 VCP.n1 VCP.t7 568.582
R99 VCP.n1 VCP.t4 568.582
R100 VCP.n0 VCP.t5 568.582
R101 VCP.n0 VCP.t6 568.582
R102 VCP.n2 VCP.n0 161.685
R103 VCP VCP.n5 161.493
R104 VCP.n4 VCP.n3 161.3
R105 VCP.n2 VCP.n1 161.3
R106 VCP.n4 VCP.n2 1.15229
R107 VCP VCP.n4 0.192464
R108 VCN.n20 VCN.t1 568.582
R109 VCN.n20 VCN.t12 568.582
R110 VCN.n21 VCN.t8 568.582
R111 VCN.n21 VCN.t5 568.582
R112 VCN.n23 VCN.t0 568.582
R113 VCN.n23 VCN.t11 568.582
R114 VCN.n19 VCN.t10 568.582
R115 VCN.n19 VCN.t7 568.582
R116 VCN.n17 VCN.t4 568.582
R117 VCN.n17 VCN.t13 568.582
R118 VCN.n15 VCN.t9 568.582
R119 VCN.n15 VCN.t6 568.582
R120 VCN.n13 VCN.t3 568.582
R121 VCN.n13 VCN.t2 568.582
R122 VCN.n11 VCN.t16 568.582
R123 VCN.n11 VCN.t17 568.582
R124 VCN.n9 VCN.t20 568.582
R125 VCN.n9 VCN.t23 568.582
R126 VCN.n7 VCN.t27 568.582
R127 VCN.n7 VCN.t18 568.582
R128 VCN.n5 VCN.t21 568.582
R129 VCN.n5 VCN.t24 568.582
R130 VCN.n3 VCN.t25 568.582
R131 VCN.n3 VCN.t14 568.582
R132 VCN.n1 VCN.t19 568.582
R133 VCN.n1 VCN.t22 568.582
R134 VCN.n0 VCN.t26 568.582
R135 VCN.n0 VCN.t15 568.582
R136 VCN.n22 VCN.n20 161.685
R137 VCN.n2 VCN.n0 161.685
R138 VCN.n22 VCN.n21 161.3
R139 VCN.n24 VCN.n23 161.3
R140 VCN VCN.n19 161.3
R141 VCN.n18 VCN.n17 161.3
R142 VCN.n16 VCN.n15 161.3
R143 VCN.n14 VCN.n13 161.3
R144 VCN.n12 VCN.n11 161.3
R145 VCN.n10 VCN.n9 161.3
R146 VCN.n8 VCN.n7 161.3
R147 VCN.n6 VCN.n5 161.3
R148 VCN.n4 VCN.n3 161.3
R149 VCN.n2 VCN.n1 161.3
R150 VCN.n14 VCN.n12 1.15229
R151 VCN.n4 VCN.n2 0.384429
R152 VCN.n6 VCN.n4 0.384429
R153 VCN.n8 VCN.n6 0.384429
R154 VCN.n10 VCN.n8 0.384429
R155 VCN.n12 VCN.n10 0.384429
R156 VCN.n16 VCN.n14 0.384429
R157 VCN.n18 VCN.n16 0.384429
R158 VCN VCN.n18 0.384429
R159 VCN VCN.n24 0.384429
R160 VCN.n24 VCN.n22 0.384429
C0 VOUT VCP 0.095466f
C1 m1_2290_2912# m1_656_2912# 0.063575f
C2 VCN m1_656_2912# 0.012098f
C3 VIP m1_1000_1400# 2.61e-19
C4 VOUT m1_1000_1400# 0.264695f
C5 m1_656_2912# li_921_2839# 0.176567f
C6 VOUT VIP 2.83e-19
C7 m1_1290_560# VIN 0.002191f
C8 VDD VIN 0.052182f
C9 VCP m1_1290_560# 0.122293f
C10 m1_2032_1400# VIN 2.61e-19
C11 VCN VIN 0.001921f
C12 VCP VDD 0.189708f
C13 m1_1000_1400# m1_1290_560# 0.030158f
C14 VIN li_921_2839# 0.005045f
C15 m1_1000_1400# VDD 0.205238f
C16 m1_2290_2912# VCP 7.67e-19
C17 m1_2032_1400# VCP 0.012244f
C18 VCN VCP 0.007309f
C19 VIP m1_1290_560# 0.008687f
C20 VOUT IB 4.56e-20
C21 VOUT m1_1290_560# 0.106559f
C22 VCP li_921_2839# 0.072348f
C23 m1_2032_1400# m1_1000_1400# 0.068533f
C24 VCN m1_1000_1400# 8.9e-22
C25 VIP VDD 0.042268f
C26 VOUT VDD 0.593108f
C27 m1_656_2912# VIN -0.004281f
C28 m1_1000_1400# li_921_2839# 0.01649f
C29 m1_2290_2912# VIP -0.004281f
C30 VIP m1_2032_1400# 0.017958f
C31 VIP VCN 0.001921f
C32 m1_2290_2912# VOUT 2.28e-19
C33 VOUT m1_2032_1400# 0.003729f
C34 VOUT VCN 6.81e-19
C35 m1_656_2912# VCP 7.67e-19
C36 VIP li_921_2839# 0.005045f
C37 VOUT li_921_2839# 0.237606f
C38 m1_656_2912# m1_1000_1400# 0.004734f
C39 VOUT m1_656_2912# 0.170068f
C40 VDD IB 0.058005f
C41 m1_1290_560# VDD 1.238624f
C42 m1_2290_2912# IB 0.001538f
C43 m1_2290_2912# m1_1290_560# 0.152062f
C44 m1_2032_1400# m1_1290_560# 0.34274f
C45 VCN IB 0.039141f
C46 VCN m1_1290_560# 6.81e-19
C47 IB li_921_2839# 0.074666f
C48 m1_2290_2912# VDD 0.306179f
C49 VCP VIN 0.00681f
C50 m1_1290_560# li_921_2839# 0.249745f
C51 m1_2032_1400# VDD 0.161777f
C52 VCN VDD 0.33811f
C53 m1_1000_1400# VIN 0.017958f
C54 VDD li_921_2839# 1.2382f
C55 m1_2290_2912# m1_2032_1400# 0.004721f
C56 m1_2290_2912# VCN 0.012689f
C57 VCN m1_2032_1400# 8.9e-22
C58 m1_2290_2912# li_921_2839# 0.140374f
C59 m1_2032_1400# li_921_2839# 0.01649f
C60 VCN li_921_2839# 0.144525f
C61 m1_656_2912# IB 0.007361f
C62 m1_656_2912# m1_1290_560# 2.28e-19
C63 m1_1000_1400# VCP 0.012244f
C64 VIP VIN 0.00161f
C65 VOUT VIN 0.00998f
C66 m1_656_2912# VDD 0.336937f
C67 VIP VCP 0.00681f
C68 VCP VSS 0.315872f
C69 VOUT VSS 5.676629f
C70 VCN VSS 6.278032f
C71 VDD.n0 VSS 3.17881f
C72 VDD.n1 VSS 0.027727f
C73 VDD.n2 VSS 0.050311f
C74 VDD.n3 VSS 0.228626f
C75 VDD.n4 VSS 0.508007f
C76 VDD.n5 VSS 0.050311f
C77 VDD.n6 VSS 0.107889f
C78 VDD.n7 VSS 0.171469f
C79 VDD.n8 VSS 0.171469f
C80 VDD.n9 VSS 0.107889f
C81 VDD.n10 VSS 0.171469f
C82 VDD.n11 VSS 0.171469f
C83 VDD.n12 VSS 0.228626f
C84 VDD.n13 VSS 0.228626f
C85 VDD.n14 VSS 0.171469f
C86 VDD.n15 VSS 0.107912f
C87 VDD.n16 VSS 0.171469f
C88 VDD.n17 VSS 0.171469f
C89 VDD.n18 VSS 0.107889f
C90 VDD.n19 VSS 0.171469f
C91 VDD.n20 VSS 0.171469f
C92 VDD.n21 VSS 0.107889f
C93 VDD.n22 VSS 0.664389f
C94 VDD.n23 VSS 1.12951f
C95 m1_1290_560# VSS 1.5249f
C96 m1_2032_1400# VSS 0.465697f
C97 m1_1000_1400# VSS 0.417183f
C98 VDD VSS 32.971313f
C99 m1_2290_2912# VSS 0.851143f
C100 VIP VSS 0.664794f
C101 IB VSS 10.031563f
C102 m1_656_2912# VSS 0.758807f
C103 li_921_2839# VSS 5.657423f
C104 VIN VSS 0.638582f
.ends
