* NGSPICE file created from TELESCOPIC_OTA_0.ext - technology: sky130A

.subckt SCM_NMOS_70610444_X2_Y1_1772172714 a_200_252# a_402_462# a_147_462#
X0 a_402_462# a_200_252# a_147_462# a_147_462# sky130_fd_pr__nfet_01v8 ad=0.147 pd=1.33 as=0.147 ps=1.33 w=1.05 l=0.15
X1 a_200_252# a_200_252# a_147_462# a_147_462# sky130_fd_pr__nfet_01v8 ad=0.147 pd=1.33 as=0.147 ps=1.33 w=1.05 l=0.15
X2 a_147_462# a_200_252# a_402_462# a_147_462# sky130_fd_pr__nfet_01v8 ad=0.147 pd=1.33 as=0.147 ps=1.33 w=1.05 l=0.15
X3 a_147_462# a_200_252# a_200_252# a_147_462# sky130_fd_pr__nfet_01v8 ad=0.27825 pd=2.63 as=0.147 ps=1.33 w=1.05 l=0.15
X4 a_402_462# a_200_252# a_147_462# a_147_462# sky130_fd_pr__nfet_01v8 ad=0.147 pd=1.33 as=0.147 ps=1.33 w=1.05 l=0.15
X5 a_200_252# a_200_252# a_147_462# a_147_462# sky130_fd_pr__nfet_01v8 ad=0.147 pd=1.33 as=0.27825 ps=2.63 w=1.05 l=0.15
X6 a_147_462# a_200_252# a_200_252# a_147_462# sky130_fd_pr__nfet_01v8 ad=0.147 pd=1.33 as=0.147 ps=1.33 w=1.05 l=0.15
X7 a_147_462# a_200_252# a_402_462# a_147_462# sky130_fd_pr__nfet_01v8 ad=0.147 pd=1.33 as=0.147 ps=1.33 w=1.05 l=0.15
C0 a_402_462# a_200_252# 0.41243f
C1 a_402_462# a_147_462# 1.49411f
C2 a_200_252# a_147_462# 4.53708f
.ends

.subckt NMOS_4T_38497018_X5_Y2_1772172711 a_230_462# a_200_252# a_147_462# a_241_2408#
X0 a_230_462# a_200_252# a_147_462# a_241_2408# sky130_fd_pr__nfet_01v8 ad=0.147 pd=1.33 as=0.147 ps=1.33 w=1.05 l=0.15
X1 a_147_462# a_200_252# a_230_462# a_241_2408# sky130_fd_pr__nfet_01v8 ad=0.147 pd=1.33 as=0.147 ps=1.33 w=1.05 l=0.15
X2 a_230_462# a_200_252# a_147_462# a_241_2408# sky130_fd_pr__nfet_01v8 ad=0.147 pd=1.33 as=0.27825 ps=2.63 w=1.05 l=0.15
X3 a_230_462# a_200_252# a_147_462# a_241_2408# sky130_fd_pr__nfet_01v8 ad=0.147 pd=1.33 as=0.147 ps=1.33 w=1.05 l=0.15
X4 a_147_462# a_200_252# a_230_462# a_241_2408# sky130_fd_pr__nfet_01v8 ad=0.147 pd=1.33 as=0.147 ps=1.33 w=1.05 l=0.15
X5 a_147_462# a_200_252# a_230_462# a_241_2408# sky130_fd_pr__nfet_01v8 ad=0.147 pd=1.33 as=0.147 ps=1.33 w=1.05 l=0.15
X6 a_230_462# a_200_252# a_147_462# a_241_2408# sky130_fd_pr__nfet_01v8 ad=0.147 pd=1.33 as=0.147 ps=1.33 w=1.05 l=0.15
X7 a_230_462# a_200_252# a_147_462# a_241_2408# sky130_fd_pr__nfet_01v8 ad=0.147 pd=1.33 as=0.147 ps=1.33 w=1.05 l=0.15
X8 a_147_462# a_200_252# a_230_462# a_241_2408# sky130_fd_pr__nfet_01v8 ad=0.147 pd=1.33 as=0.147 ps=1.33 w=1.05 l=0.15
X9 a_230_462# a_200_252# a_147_462# a_241_2408# sky130_fd_pr__nfet_01v8 ad=0.147 pd=1.33 as=0.147 ps=1.33 w=1.05 l=0.15
X10 a_230_462# a_200_252# a_147_462# a_241_2408# sky130_fd_pr__nfet_01v8 ad=0.147 pd=1.33 as=0.147 ps=1.33 w=1.05 l=0.15
X11 a_147_462# a_200_252# a_230_462# a_241_2408# sky130_fd_pr__nfet_01v8 ad=0.27825 pd=2.63 as=0.147 ps=1.33 w=1.05 l=0.15
X12 a_147_462# a_200_252# a_230_462# a_241_2408# sky130_fd_pr__nfet_01v8 ad=0.147 pd=1.33 as=0.147 ps=1.33 w=1.05 l=0.15
X13 a_147_462# a_200_252# a_230_462# a_241_2408# sky130_fd_pr__nfet_01v8 ad=0.147 pd=1.33 as=0.147 ps=1.33 w=1.05 l=0.15
X14 a_230_462# a_200_252# a_147_462# a_241_2408# sky130_fd_pr__nfet_01v8 ad=0.147 pd=1.33 as=0.147 ps=1.33 w=1.05 l=0.15
X15 a_230_462# a_200_252# a_147_462# a_241_2408# sky130_fd_pr__nfet_01v8 ad=0.147 pd=1.33 as=0.147 ps=1.33 w=1.05 l=0.15
X16 a_147_462# a_200_252# a_230_462# a_241_2408# sky130_fd_pr__nfet_01v8 ad=0.27825 pd=2.63 as=0.147 ps=1.33 w=1.05 l=0.15
X17 a_230_462# a_200_252# a_147_462# a_241_2408# sky130_fd_pr__nfet_01v8 ad=0.147 pd=1.33 as=0.27825 ps=2.63 w=1.05 l=0.15
X18 a_147_462# a_200_252# a_230_462# a_241_2408# sky130_fd_pr__nfet_01v8 ad=0.147 pd=1.33 as=0.147 ps=1.33 w=1.05 l=0.15
X19 a_147_462# a_200_252# a_230_462# a_241_2408# sky130_fd_pr__nfet_01v8 ad=0.147 pd=1.33 as=0.147 ps=1.33 w=1.05 l=0.15
C0 a_147_462# a_230_462# 7.35647f
C1 a_147_462# a_200_252# 1.4053f
C2 a_230_462# a_200_252# 1.49984f
C3 a_230_462# a_241_2408# 0.886886f
C4 a_147_462# a_241_2408# 1.49254f
C5 a_200_252# a_241_2408# 4.84974f
.ends

.subckt PMOS_S_72546662_X5_Y1_1772172713 a_230_462# a_200_252# w_0_0# VSUBS
X0 a_230_462# a_200_252# w_0_0# w_0_0# sky130_fd_pr__pfet_01v8 ad=0.147 pd=1.33 as=0.147 ps=1.33 w=1.05 l=0.15
X1 w_0_0# a_200_252# a_230_462# w_0_0# sky130_fd_pr__pfet_01v8 ad=0.147 pd=1.33 as=0.147 ps=1.33 w=1.05 l=0.15
X2 w_0_0# a_200_252# a_230_462# w_0_0# sky130_fd_pr__pfet_01v8 ad=0.147 pd=1.33 as=0.147 ps=1.33 w=1.05 l=0.15
X3 a_230_462# a_200_252# w_0_0# w_0_0# sky130_fd_pr__pfet_01v8 ad=0.147 pd=1.33 as=0.147 ps=1.33 w=1.05 l=0.15
X4 a_230_462# a_200_252# w_0_0# w_0_0# sky130_fd_pr__pfet_01v8 ad=0.147 pd=1.33 as=0.147 ps=1.33 w=1.05 l=0.15
X5 w_0_0# a_200_252# a_230_462# w_0_0# sky130_fd_pr__pfet_01v8 ad=0.27825 pd=2.63 as=0.147 ps=1.33 w=1.05 l=0.15
X6 a_230_462# a_200_252# w_0_0# w_0_0# sky130_fd_pr__pfet_01v8 ad=0.147 pd=1.33 as=0.27825 ps=2.63 w=1.05 l=0.15
X7 w_0_0# a_200_252# a_230_462# w_0_0# sky130_fd_pr__pfet_01v8 ad=0.147 pd=1.33 as=0.147 ps=1.33 w=1.05 l=0.15
X8 w_0_0# a_200_252# a_230_462# w_0_0# sky130_fd_pr__pfet_01v8 ad=0.147 pd=1.33 as=0.147 ps=1.33 w=1.05 l=0.15
X9 a_230_462# a_200_252# w_0_0# w_0_0# sky130_fd_pr__pfet_01v8 ad=0.147 pd=1.33 as=0.147 ps=1.33 w=1.05 l=0.15
C0 a_200_252# a_230_462# 0.46324f
C1 a_200_252# w_0_0# 2.64737f
C2 a_230_462# w_0_0# 3.72346f
C3 a_230_462# VSUBS 0.20286f
C4 a_200_252# VSUBS 0.342728f
C5 w_0_0# VSUBS 5.87388f
.ends

.subckt PMOS_4T_58191883_X5_Y1_1772172712 a_230_462# a_200_252# w_0_0# a_147_462#
+ VSUBS
X0 a_230_462# a_200_252# a_147_462# w_0_0# sky130_fd_pr__pfet_01v8 ad=0.147 pd=1.33 as=0.147 ps=1.33 w=1.05 l=0.15
X1 a_147_462# a_200_252# a_230_462# w_0_0# sky130_fd_pr__pfet_01v8 ad=0.147 pd=1.33 as=0.147 ps=1.33 w=1.05 l=0.15
X2 a_147_462# a_200_252# a_230_462# w_0_0# sky130_fd_pr__pfet_01v8 ad=0.147 pd=1.33 as=0.147 ps=1.33 w=1.05 l=0.15
X3 a_230_462# a_200_252# a_147_462# w_0_0# sky130_fd_pr__pfet_01v8 ad=0.147 pd=1.33 as=0.147 ps=1.33 w=1.05 l=0.15
X4 a_230_462# a_200_252# a_147_462# w_0_0# sky130_fd_pr__pfet_01v8 ad=0.147 pd=1.33 as=0.147 ps=1.33 w=1.05 l=0.15
X5 a_147_462# a_200_252# a_230_462# w_0_0# sky130_fd_pr__pfet_01v8 ad=0.27825 pd=2.63 as=0.147 ps=1.33 w=1.05 l=0.15
X6 a_230_462# a_200_252# a_147_462# w_0_0# sky130_fd_pr__pfet_01v8 ad=0.147 pd=1.33 as=0.27825 ps=2.63 w=1.05 l=0.15
X7 a_147_462# a_200_252# a_230_462# w_0_0# sky130_fd_pr__pfet_01v8 ad=0.147 pd=1.33 as=0.147 ps=1.33 w=1.05 l=0.15
X8 a_147_462# a_200_252# a_230_462# w_0_0# sky130_fd_pr__pfet_01v8 ad=0.147 pd=1.33 as=0.147 ps=1.33 w=1.05 l=0.15
X9 a_230_462# a_200_252# a_147_462# w_0_0# sky130_fd_pr__pfet_01v8 ad=0.147 pd=1.33 as=0.147 ps=1.33 w=1.05 l=0.15
C0 a_230_462# w_0_0# 0.200891f
C1 a_200_252# a_147_462# 0.460388f
C2 a_200_252# a_230_462# 0.46324f
C3 a_200_252# w_0_0# 2.05106f
C4 a_147_462# a_230_462# 3.45985f
C5 a_147_462# w_0_0# 0.376502f
C6 a_230_462# VSUBS 0.20286f
C7 a_147_462# VSUBS 0.301744f
C8 a_200_252# VSUBS 0.342728f
C9 w_0_0# VSUBS 5.6573f
.ends

.subckt TELESCOPIC_OTA_0 IB VCN VOUT VIP VIN VCP VSS VDD
XSCM_NMOS_70610444_X2_Y1_1772172714_0 IB m1_914_8540# VSS SCM_NMOS_70610444_X2_Y1_1772172714
XNMOS_4T_38497018_X5_Y2_1772172711_0 m2_488_4368# VIN m1_914_8540# VSS NMOS_4T_38497018_X5_Y2_1772172711
XNMOS_4T_38497018_X5_Y2_1772172711_2 VOUT VCN m2_488_4368# VSS NMOS_4T_38497018_X5_Y2_1772172711
XNMOS_4T_38497018_X5_Y2_1772172711_1 m2_1864_4368# VIP m1_914_8540# VSS NMOS_4T_38497018_X5_Y2_1772172711
XNMOS_4T_38497018_X5_Y2_1772172711_3 m1_946_560# VCN m2_1864_4368# VSS NMOS_4T_38497018_X5_Y2_1772172711
XPMOS_S_72546662_X5_Y1_1772172713_0 m1_570_1400# m1_946_560# VDD VSS PMOS_S_72546662_X5_Y1_1772172713
XPMOS_S_72546662_X5_Y1_1772172713_1 m1_1774_1400# m1_946_560# VDD VSS PMOS_S_72546662_X5_Y1_1772172713
XPMOS_4T_58191883_X5_Y1_1772172712_0 VOUT VCP VDD m1_570_1400# VSS PMOS_4T_58191883_X5_Y1_1772172712
XPMOS_4T_58191883_X5_Y1_1772172712_1 m1_946_560# VCP VDD m1_1774_1400# VSS PMOS_4T_58191883_X5_Y1_1772172712
R0 IB.n4 IB.t2 568.582
R1 IB.n4 IB.t0 568.582
R2 IB.n3 IB.t8 568.582
R3 IB.n3 IB.t9 568.582
R4 IB.n1 IB.t10 568.582
R5 IB.n1 IB.t11 568.582
R6 IB.n0 IB.t6 568.582
R7 IB.n0 IB.t4 568.582
R8 IB.n8 IB.n6 185.845
R9 IB.n8 IB.n7 185.462
R10 IB.n5 IB.n4 161.685
R11 IB.n2 IB.n0 161.685
R12 IB.n5 IB.n3 161.3
R13 IB.n2 IB.n1 161.3
R14 IB.n7 IB.t1 16.0005
R15 IB.n7 IB.t3 16.0005
R16 IB.n6 IB.t5 16.0005
R17 IB.n6 IB.t7 16.0005
R18 IB IB.n5 5.438
R19 IB IB.n8 5.438
R20 IB.n5 IB.n2 0.384429
R21 VIN.n4 VIN.t2 568.582
R22 VIN.n4 VIN.t5 568.582
R23 VIN.n5 VIN.t9 568.582
R24 VIN.n5 VIN.t1 568.582
R25 VIN.n3 VIN.t3 568.582
R26 VIN.n3 VIN.t8 568.582
R27 VIN.n1 VIN.t0 568.582
R28 VIN.n1 VIN.t4 568.582
R29 VIN.n0 VIN.t6 568.582
R30 VIN.n0 VIN.t11 568.582
R31 VIN.n12 VIN.t17 568.582
R32 VIN.n12 VIN.t18 568.582
R33 VIN.n13 VIN.t7 568.582
R34 VIN.n13 VIN.t12 568.582
R35 VIN.n11 VIN.t15 568.582
R36 VIN.n11 VIN.t19 568.582
R37 VIN.n9 VIN.t10 568.582
R38 VIN.n9 VIN.t13 568.582
R39 VIN.n8 VIN.t14 568.582
R40 VIN.n8 VIN.t16 568.582
R41 VIN.n6 VIN.n4 161.685
R42 VIN.n2 VIN.n0 161.685
R43 VIN.n14 VIN.n12 161.685
R44 VIN.n10 VIN.n8 161.685
R45 VIN.n6 VIN.n5 161.3
R46 VIN.n7 VIN.n3 161.3
R47 VIN.n2 VIN.n1 161.3
R48 VIN.n14 VIN.n13 161.3
R49 VIN.n15 VIN.n11 161.3
R50 VIN.n10 VIN.n9 161.3
R51 VIN VIN.n7 5.813
R52 VIN VIN.n15 5.813
R53 VIN.n7 VIN.n2 0.384429
R54 VIN.n7 VIN.n6 0.384429
R55 VIN.n15 VIN.n10 0.384429
R56 VIN.n15 VIN.n14 0.384429
R57 VCN.n4 VCN.t11 568.582
R58 VCN.n4 VCN.t6 568.582
R59 VCN.n5 VCN.t4 568.582
R60 VCN.n5 VCN.t0 568.582
R61 VCN.n3 VCN.t8 568.582
R62 VCN.n3 VCN.t3 568.582
R63 VCN.n1 VCN.t1 568.582
R64 VCN.n1 VCN.t9 568.582
R65 VCN.n0 VCN.t5 568.582
R66 VCN.n0 VCN.t2 568.582
R67 VCN.n29 VCN.t16 568.582
R68 VCN.n29 VCN.t14 568.582
R69 VCN.n30 VCN.t13 568.582
R70 VCN.n30 VCN.t10 568.582
R71 VCN.n28 VCN.t19 568.582
R72 VCN.n28 VCN.t15 568.582
R73 VCN.n26 VCN.t12 568.582
R74 VCN.n26 VCN.t7 568.582
R75 VCN.n25 VCN.t18 568.582
R76 VCN.n25 VCN.t17 568.582
R77 VCN.n12 VCN.t22 568.582
R78 VCN.n12 VCN.t25 568.582
R79 VCN.n13 VCN.t29 568.582
R80 VCN.n13 VCN.t21 568.582
R81 VCN.n11 VCN.t23 568.582
R82 VCN.n11 VCN.t28 568.582
R83 VCN.n9 VCN.t20 568.582
R84 VCN.n9 VCN.t24 568.582
R85 VCN.n8 VCN.t26 568.582
R86 VCN.n8 VCN.t31 568.582
R87 VCN.n20 VCN.t37 568.582
R88 VCN.n20 VCN.t38 568.582
R89 VCN.n21 VCN.t27 568.582
R90 VCN.n21 VCN.t32 568.582
R91 VCN.n19 VCN.t35 568.582
R92 VCN.n19 VCN.t39 568.582
R93 VCN.n17 VCN.t30 568.582
R94 VCN.n17 VCN.t33 568.582
R95 VCN.n16 VCN.t34 568.582
R96 VCN.n16 VCN.t36 568.582
R97 VCN.n6 VCN.n4 161.685
R98 VCN.n2 VCN.n0 161.685
R99 VCN.n31 VCN.n29 161.685
R100 VCN.n27 VCN.n25 161.685
R101 VCN.n14 VCN.n12 161.685
R102 VCN.n10 VCN.n8 161.685
R103 VCN.n22 VCN.n20 161.685
R104 VCN.n18 VCN.n16 161.685
R105 VCN.n6 VCN.n5 161.3
R106 VCN.n7 VCN.n3 161.3
R107 VCN.n2 VCN.n1 161.3
R108 VCN.n31 VCN.n30 161.3
R109 VCN.n32 VCN.n28 161.3
R110 VCN.n27 VCN.n26 161.3
R111 VCN.n14 VCN.n13 161.3
R112 VCN.n15 VCN.n11 161.3
R113 VCN.n10 VCN.n9 161.3
R114 VCN.n22 VCN.n21 161.3
R115 VCN.n23 VCN.n19 161.3
R116 VCN.n18 VCN.n17 161.3
R117 VCN VCN.n24 11.688
R118 VCN.n24 VCN.n15 5.813
R119 VCN.n24 VCN.n23 5.813
R120 VCN VCN.n7 5.813
R121 VCN VCN.n32 5.813
R122 VCN.n7 VCN.n2 0.384429
R123 VCN.n7 VCN.n6 0.384429
R124 VCN.n32 VCN.n27 0.384429
R125 VCN.n32 VCN.n31 0.384429
R126 VCN.n15 VCN.n10 0.384429
R127 VCN.n15 VCN.n14 0.384429
R128 VCN.n23 VCN.n18 0.384429
R129 VCN.n23 VCN.n22 0.384429
R130 VIP.n4 VIP.t11 568.582
R131 VIP.n4 VIP.t6 568.582
R132 VIP.n5 VIP.t4 568.582
R133 VIP.n5 VIP.t0 568.582
R134 VIP.n3 VIP.t8 568.582
R135 VIP.n3 VIP.t3 568.582
R136 VIP.n1 VIP.t1 568.582
R137 VIP.n1 VIP.t9 568.582
R138 VIP.n0 VIP.t5 568.582
R139 VIP.n0 VIP.t2 568.582
R140 VIP.n12 VIP.t16 568.582
R141 VIP.n12 VIP.t14 568.582
R142 VIP.n13 VIP.t13 568.582
R143 VIP.n13 VIP.t10 568.582
R144 VIP.n11 VIP.t19 568.582
R145 VIP.n11 VIP.t15 568.582
R146 VIP.n9 VIP.t12 568.582
R147 VIP.n9 VIP.t7 568.582
R148 VIP.n8 VIP.t18 568.582
R149 VIP.n8 VIP.t17 568.582
R150 VIP.n6 VIP.n4 161.685
R151 VIP.n2 VIP.n0 161.685
R152 VIP.n14 VIP.n12 161.685
R153 VIP.n10 VIP.n8 161.685
R154 VIP.n6 VIP.n5 161.3
R155 VIP.n7 VIP.n3 161.3
R156 VIP.n2 VIP.n1 161.3
R157 VIP.n14 VIP.n13 161.3
R158 VIP.n15 VIP.n11 161.3
R159 VIP.n10 VIP.n9 161.3
R160 VIP VIP.n7 5.813
R161 VIP VIP.n15 5.813
R162 VIP.n7 VIP.n2 0.384429
R163 VIP.n7 VIP.n6 0.384429
R164 VIP.n15 VIP.n10 0.384429
R165 VIP.n15 VIP.n14 0.384429
R166 VDD.n14 VDD.n7 379.685
R167 VDD.n11 VDD.n7 379.685
R168 VDD.n23 VDD.n21 379.685
R169 VDD.n13 VDD.n11 379.3
R170 VDD.n16 VDD.n4 379.3
R171 VDD.n21 VDD.n20 379.3
R172 VDD.n14 VDD.n13 379.3
R173 VDD.n16 VDD.n15 379.3
R174 VDD.n20 VDD.n2 379.3
R175 VDD.n24 VDD.n23 379.3
R176 VDD.n6 VDD.n1 189.43
R177 VDD.n25 VDD.n1 86.0187
R178 VDD.n1 VDD 80.7148
R179 VDD.n9 VDD.n8 27.0177
R180 VDD.n12 VDD.n5 27.0177
R181 VDD.n18 VDD.n17 27.0177
R182 VDD.n19 VDD.n3 27.0177
R183 VDD.n10 VDD.n0 17.4775
R184 VDD.n7 VDD.n6 13.5091
R185 VDD.n8 VDD.n7 13.5091
R186 VDD.n13 VDD.n9 13.5091
R187 VDD.n13 VDD.n12 13.5091
R188 VDD.n16 VDD.n5 13.5091
R189 VDD.n17 VDD.n16 13.5091
R190 VDD.n20 VDD.n18 13.5091
R191 VDD.n20 VDD.n19 13.5091
R192 VDD.n23 VDD.n3 13.5091
R193 VDD.n23 VDD.n22 13.5091
R194 VDD VDD.n0 13.1869
R195 VDD.n25 VDD.n24 9.4105
R196 VDD.n26 VDD.n0 4.28995
R197 VDD.n26 VDD.n25 3.48629
R198 VDD.n15 VDD.n14 0.384429
R199 VDD.n15 VDD.n2 0.384429
R200 VDD.n24 VDD.n2 0.384429
R201 VDD.n21 VDD.n4 0.384429
R202 VDD.n11 VDD.n10 0.192464
R203 VDD.n10 VDD.n4 0.192464
R204 VDD VDD.n26 0.176153
R205 VCP.n14 VCP.t5 568.582
R206 VCP.n14 VCP.t3 568.582
R207 VCP.n15 VCP.t2 568.582
R208 VCP.n15 VCP.t0 568.582
R209 VCP.n13 VCP.t8 568.582
R210 VCP.n13 VCP.t4 568.582
R211 VCP.n11 VCP.t1 568.582
R212 VCP.n11 VCP.t9 568.582
R213 VCP.n9 VCP.t7 568.582
R214 VCP.n9 VCP.t6 568.582
R215 VCP.n7 VCP.t16 568.582
R216 VCP.n7 VCP.t17 568.582
R217 VCP.n5 VCP.t19 568.582
R218 VCP.n5 VCP.t11 568.582
R219 VCP.n3 VCP.t14 568.582
R220 VCP.n3 VCP.t18 568.582
R221 VCP.n1 VCP.t10 568.582
R222 VCP.n1 VCP.t12 568.582
R223 VCP.n0 VCP.t13 568.582
R224 VCP.n0 VCP.t15 568.582
R225 VCP.n16 VCP.n14 161.685
R226 VCP.n2 VCP.n0 161.685
R227 VCP.n16 VCP.n15 161.3
R228 VCP VCP.n13 161.3
R229 VCP.n12 VCP.n11 161.3
R230 VCP.n10 VCP.n9 161.3
R231 VCP.n8 VCP.n7 161.3
R232 VCP.n6 VCP.n5 161.3
R233 VCP.n4 VCP.n3 161.3
R234 VCP.n2 VCP.n1 161.3
R235 VCP.n10 VCP.n8 1.15229
R236 VCP.n4 VCP.n2 0.384429
R237 VCP.n6 VCP.n4 0.384429
R238 VCP.n8 VCP.n6 0.384429
R239 VCP.n12 VCP.n10 0.384429
R240 VCP VCP.n12 0.384429
R241 VCP VCP.n16 0.384429
C0 VDD VCN 0.342686f
C1 VCN VOUT 0.087381f
C2 VIP m2_1864_4368# -1.65e-19
C3 m1_914_8540# m2_1864_4368# 0.072795f
C4 VIN m2_488_4368# -0.006929f
C5 VDD VOUT 0.938897f
C6 m2_488_4368# IB 2.28e-20
C7 VCP m1_1774_1400# 0.014216f
C8 m1_946_560# VCP 0.165605f
C9 VIN IB 0.004027f
C10 m1_570_1400# VDD 0.252922f
C11 m1_1774_1400# m2_1864_4368# 0.01307f
C12 VCP m2_488_4368# 0.006499f
C13 m1_570_1400# VOUT 0.50912f
C14 m1_946_560# m2_1864_4368# 0.006558f
C15 VCN VIP 0.011124f
C16 VCN m1_914_8540# 0.009468f
C17 m2_488_4368# m2_1864_4368# 0.151386f
C18 VDD VIP 0.008557f
C19 VDD m1_914_8540# 0.091053f
C20 VOUT m1_914_8540# 0.001779f
C21 VCN m1_946_560# 0.084752f
C22 VDD m1_1774_1400# 0.180861f
C23 VCN m2_488_4368# 0.700494f
C24 VDD m1_946_560# 1.630481f
C25 VCP m2_1864_4368# 0.006499f
C26 VOUT m1_1774_1400# 0.004936f
C27 VCN VIN 0.011124f
C28 VOUT m1_946_560# 0.1257f
C29 VDD m2_488_4368# 0.593322f
C30 m1_570_1400# m1_1774_1400# 0.068531f
C31 VIP m1_914_8540# 0.131487f
C32 VOUT m2_488_4368# 0.007058f
C33 VDD VIN 0.086679f
C34 m1_570_1400# m1_946_560# 0.023799f
C35 VDD IB 0.008543f
C36 VCN VCP 0.018574f
C37 m1_570_1400# m2_488_4368# 0.01307f
C38 VCN m2_1864_4368# 0.70242f
C39 VDD VCP 0.264427f
C40 m1_946_560# m1_914_8540# 0.001779f
C41 VOUT VCP 0.14596f
C42 VDD m2_1864_4368# 0.346403f
C43 m1_914_8540# m2_488_4368# 0.110415f
C44 VOUT m2_1864_4368# 0.004058f
C45 VIP VIN 0.07342f
C46 m1_570_1400# VCP 0.014216f
C47 m1_914_8540# VIN 0.272549f
C48 m1_946_560# m1_1774_1400# 0.625537f
C49 m1_914_8540# IB 0.125749f
C50 m1_946_560# m2_488_4368# 0.002237f
C51 m1_946_560# VSS 1.666807f
C52 VOUT VSS 12.303227f
C53 VCP VSS 0.904071f
C54 VCP.t15 VSS 0.024426f
C55 VCP.t13 VSS 0.024426f
C56 VCP.n0 VSS 0.170769f
C57 VCP.t12 VSS 0.024426f
C58 VCP.t10 VSS 0.024426f
C59 VCP.n1 VSS 0.170354f
C60 VCP.n2 VSS 0.380839f
C61 VCP.t18 VSS 0.024426f
C62 VCP.t14 VSS 0.024426f
C63 VCP.n3 VSS 0.170354f
C64 VCP.n4 VSS 0.206314f
C65 VCP.t11 VSS 0.024426f
C66 VCP.t19 VSS 0.024426f
C67 VCP.n5 VSS 0.170354f
C68 VCP.n6 VSS 0.206314f
C69 VCP.t17 VSS 0.024426f
C70 VCP.t16 VSS 0.024426f
C71 VCP.n7 VSS 0.170354f
C72 VCP.n8 VSS 0.310087f
C73 VCP.t6 VSS 0.024426f
C74 VCP.t7 VSS 0.024426f
C75 VCP.n9 VSS 0.170354f
C76 VCP.n10 VSS 0.310087f
C77 VCP.t9 VSS 0.024426f
C78 VCP.t1 VSS 0.024426f
C79 VCP.n11 VSS 0.170354f
C80 VCP.n12 VSS 0.206314f
C81 VCP.t4 VSS 0.024426f
C82 VCP.t8 VSS 0.024426f
C83 VCP.n13 VSS 0.170354f
C84 VCP.t3 VSS 0.024426f
C85 VCP.t5 VSS 0.024426f
C86 VCP.n14 VSS 0.170769f
C87 VCP.t0 VSS 0.024426f
C88 VCP.t2 VSS 0.024426f
C89 VCP.n15 VSS 0.170354f
C90 VCP.n16 VSS 0.380839f
C91 VDD.n0 VSS 1.05655f
C92 VDD.n1 VSS 3.96982f
C93 VDD.n2 VSS 0.027996f
C94 VDD.n3 VSS 0.346269f
C95 VDD.n4 VSS 0.023721f
C96 VDD.n5 VSS 0.346269f
C97 VDD.n6 VSS 1.85749f
C98 VDD.n7 VSS 0.217919f
C99 VDD.n8 VSS 0.346269f
C100 VDD.n9 VSS 0.346269f
C101 VDD.n10 VSS 0.555294f
C102 VDD.n11 VSS 0.046524f
C103 VDD.n12 VSS 0.346269f
C104 VDD.n13 VSS 0.217873f
C105 VDD.n14 VSS 0.050799f
C106 VDD.n15 VSS 0.027996f
C107 VDD.n16 VSS 0.217873f
C108 VDD.n17 VSS 0.346269f
C109 VDD.n18 VSS 0.346269f
C110 VDD.n19 VSS 0.346269f
C111 VDD.n20 VSS 0.217873f
C112 VDD.n21 VSS 0.050799f
C113 VDD.n22 VSS 1.26965f
C114 VDD.n23 VSS 0.217896f
C115 VDD.n24 VSS 0.055354f
C116 VDD.n25 VSS 1.8433f
C117 VDD.n26 VSS 1.58893f
C118 VCN.t2 VSS 0.009751f
C119 VCN.t5 VSS 0.009751f
C120 VCN.n0 VSS 0.068173f
C121 VCN.t9 VSS 0.009751f
C122 VCN.t1 VSS 0.009751f
C123 VCN.n1 VSS 0.068007f
C124 VCN.n2 VSS 0.152036f
C125 VCN.t3 VSS 0.009751f
C126 VCN.t8 VSS 0.009751f
C127 VCN.n3 VSS 0.068007f
C128 VCN.t6 VSS 0.009751f
C129 VCN.t11 VSS 0.009751f
C130 VCN.n4 VSS 0.068173f
C131 VCN.t0 VSS 0.009751f
C132 VCN.t4 VSS 0.009751f
C133 VCN.n5 VSS 0.068007f
C134 VCN.n6 VSS 0.152036f
C135 VCN.n7 VSS 0.100093f
C136 VCN.t31 VSS 0.009751f
C137 VCN.t26 VSS 0.009751f
C138 VCN.n8 VSS 0.068173f
C139 VCN.t24 VSS 0.009751f
C140 VCN.t20 VSS 0.009751f
C141 VCN.n9 VSS 0.068007f
C142 VCN.n10 VSS 0.152036f
C143 VCN.t28 VSS 0.009751f
C144 VCN.t23 VSS 0.009751f
C145 VCN.n11 VSS 0.068007f
C146 VCN.t25 VSS 0.009751f
C147 VCN.t22 VSS 0.009751f
C148 VCN.n12 VSS 0.068173f
C149 VCN.t21 VSS 0.009751f
C150 VCN.t29 VSS 0.009751f
C151 VCN.n13 VSS 0.068007f
C152 VCN.n14 VSS 0.152036f
C153 VCN.n15 VSS 0.100093f
C154 VCN.t36 VSS 0.009751f
C155 VCN.t34 VSS 0.009751f
C156 VCN.n16 VSS 0.068173f
C157 VCN.t33 VSS 0.009751f
C158 VCN.t30 VSS 0.009751f
C159 VCN.n17 VSS 0.068007f
C160 VCN.n18 VSS 0.152036f
C161 VCN.t39 VSS 0.009751f
C162 VCN.t35 VSS 0.009751f
C163 VCN.n19 VSS 0.068007f
C164 VCN.t38 VSS 0.009751f
C165 VCN.t37 VSS 0.009751f
C166 VCN.n20 VSS 0.068173f
C167 VCN.t32 VSS 0.009751f
C168 VCN.t27 VSS 0.009751f
C169 VCN.n21 VSS 0.068007f
C170 VCN.n22 VSS 0.152036f
C171 VCN.n23 VSS 0.100093f
C172 VCN.n24 VSS 0.415906f
C173 VCN.t17 VSS 0.009751f
C174 VCN.t18 VSS 0.009751f
C175 VCN.n25 VSS 0.068173f
C176 VCN.t7 VSS 0.009751f
C177 VCN.t12 VSS 0.009751f
C178 VCN.n26 VSS 0.068007f
C179 VCN.n27 VSS 0.152036f
C180 VCN.t15 VSS 0.009751f
C181 VCN.t19 VSS 0.009751f
C182 VCN.n28 VSS 0.068007f
C183 VCN.t14 VSS 0.009751f
C184 VCN.t16 VSS 0.009751f
C185 VCN.n29 VSS 0.068173f
C186 VCN.t10 VSS 0.009751f
C187 VCN.t13 VSS 0.009751f
C188 VCN.n30 VSS 0.068007f
C189 VCN.n31 VSS 0.152036f
C190 VCN.n32 VSS 0.100093f
C191 m1_1774_1400# VSS 0.384129f
C192 m1_570_1400# VSS 0.337671f
C193 VDD VSS 30.721193f
C194 m2_1864_4368# VSS 2.909787f
C195 VIP VSS 4.834504f
C196 m2_488_4368# VSS 2.669248f
C197 VCN VSS 10.092821f
C198 m1_914_8540# VSS 4.832892f
C199 VIN VSS 4.722605f
C200 IB VSS 4.72386f
.ends
