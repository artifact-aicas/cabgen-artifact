* NGSPICE file created from TELESCOPIC_OTA_0.ext - technology: sky130A

.subckt SCM_NMOS_70610444_X2_Y1_1772172714 a_200_252# a_402_462# a_147_462#
X0 a_402_462# a_200_252# a_147_462# a_147_462# sky130_fd_pr__nfet_01v8 ad=0.147 pd=1.33 as=0.147 ps=1.33 w=1.05 l=0.15 M=4
X1 a_200_252# a_200_252# a_147_462# a_147_462# sky130_fd_pr__nfet_01v8 ad=0.147 pd=1.33 as=0.147 ps=1.33 w=1.05 l=0.15 M=4
.ends

.subckt NMOS_4T_38497018_X5_Y2_1772172711 a_230_462# a_200_252# a_147_462# a_241_2408#
X0 a_230_462# a_200_252# a_147_462# a_241_2408# sky130_fd_pr__nfet_01v8 ad=0.147 pd=1.33 as=0.147 ps=1.33 w=1.05 l=0.15 M=20
.ends

.subckt PMOS_S_72546662_X5_Y1_1772172713 a_230_462# a_200_252# w_0_0#
X0 a_230_462# a_200_252# w_0_0# w_0_0# sky130_fd_pr__pfet_01v8 ad=0.147 pd=1.33 as=0.147 ps=1.33 w=1.05 l=0.15 M=10
.ends

.subckt PMOS_4T_58191883_X5_Y1_1772172712 a_230_462# a_200_252# w_0_0# a_147_462#
X0 a_230_462# a_200_252# a_147_462# w_0_0# sky130_fd_pr__pfet_01v8 ad=0.147 pd=1.33 as=0.147 ps=1.33 w=1.05 l=0.15 M=10
.ends

.subckt TELESCOPIC_OTA_0 IB VCN VOUT VIP VIN VCP VSS VDD
XSCM_NMOS_70610444_X2_Y1_1772172714_0 IB m1_914_8540# VSS SCM_NMOS_70610444_X2_Y1_1772172714
XNMOS_4T_38497018_X5_Y2_1772172711_0 m2_488_4368# VIN m1_914_8540# VSS NMOS_4T_38497018_X5_Y2_1772172711
XNMOS_4T_38497018_X5_Y2_1772172711_2 VOUT VCN m2_488_4368# VSS NMOS_4T_38497018_X5_Y2_1772172711
XNMOS_4T_38497018_X5_Y2_1772172711_1 m2_1864_4368# VIP m1_914_8540# VSS NMOS_4T_38497018_X5_Y2_1772172711
XNMOS_4T_38497018_X5_Y2_1772172711_3 m1_946_560# VCN m2_1864_4368# VSS NMOS_4T_38497018_X5_Y2_1772172711
XPMOS_S_72546662_X5_Y1_1772172713_0 m1_570_1400# m1_946_560# VDD PMOS_S_72546662_X5_Y1_1772172713
XPMOS_S_72546662_X5_Y1_1772172713_1 m1_1774_1400# m1_946_560# VDD PMOS_S_72546662_X5_Y1_1772172713
XPMOS_4T_58191883_X5_Y1_1772172712_0 VOUT VCP VDD m1_570_1400# PMOS_4T_58191883_X5_Y1_1772172712
XPMOS_4T_58191883_X5_Y1_1772172712_1 m1_946_560# VCP VDD m1_1774_1400# PMOS_4T_58191883_X5_Y1_1772172712
.ends
