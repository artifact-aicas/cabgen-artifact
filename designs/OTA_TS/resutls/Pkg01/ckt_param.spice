.param VDD=1.8 VCM=1.2 VCP=0.6 VCN=1.4 IB=50u vi=0.01 fi=100000 W1=21 L1=0.15 NF1=20 W3=10.5 L3=0.15 NF3=10 WB=4.2 LB=0.15 NFB=4 WT=4.2 LT=0.15 NFT=4 W11=10.5 L11=0.15 NF11=10 W7=21 L7=0.15 NF7=20
