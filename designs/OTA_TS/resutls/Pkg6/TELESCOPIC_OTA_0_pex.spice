* NGSPICE file created from TELESCOPIC_OTA_0.ext - technology: sky130A

.subckt NMOS_4T_14241495_X2_Y1_1774869423 a_147_525# a_200_252# a_241_1232# a_230_525#
X0 a_230_525# a_200_252# a_147_525# a_241_1232# sky130_fd_pr__nfet_01v8 ad=0.0588 pd=0.7 as=0.0588 ps=0.7 w=0.42 l=0.15
X1 a_147_525# a_200_252# a_230_525# a_241_1232# sky130_fd_pr__nfet_01v8 ad=0.1113 pd=1.37 as=0.0588 ps=0.7 w=0.42 l=0.15
X2 a_230_525# a_200_252# a_147_525# a_241_1232# sky130_fd_pr__nfet_01v8 ad=0.0588 pd=0.7 as=0.1113 ps=1.37 w=0.42 l=0.15
X3 a_147_525# a_200_252# a_230_525# a_241_1232# sky130_fd_pr__nfet_01v8 ad=0.0588 pd=0.7 as=0.0588 ps=0.7 w=0.42 l=0.15
C0 a_200_252# a_147_525# 0.194442f
C1 a_230_525# a_147_525# 1.34269f
C2 a_230_525# a_200_252# 0.202256f
C3 a_230_525# a_241_1232# 0.172998f
C4 a_147_525# a_241_1232# 0.532969f
C5 a_200_252# a_241_1232# 1.28125f
.ends

.subckt PMOS_S_70514696_X4_Y1_1774869426 a_200_252# w_0_0# a_230_525# VSUBS
X0 w_0_0# a_200_252# a_230_525# w_0_0# sky130_fd_pr__pfet_01v8 ad=0.0588 pd=0.7 as=0.0588 ps=0.7 w=0.42 l=0.15
X1 w_0_0# a_200_252# a_230_525# w_0_0# sky130_fd_pr__pfet_01v8 ad=0.1113 pd=1.37 as=0.0588 ps=0.7 w=0.42 l=0.15
X2 a_230_525# a_200_252# w_0_0# w_0_0# sky130_fd_pr__pfet_01v8 ad=0.0588 pd=0.7 as=0.0588 ps=0.7 w=0.42 l=0.15
X3 a_230_525# a_200_252# w_0_0# w_0_0# sky130_fd_pr__pfet_01v8 ad=0.0588 pd=0.7 as=0.1113 ps=1.37 w=0.42 l=0.15
X4 w_0_0# a_200_252# a_230_525# w_0_0# sky130_fd_pr__pfet_01v8 ad=0.0588 pd=0.7 as=0.0588 ps=0.7 w=0.42 l=0.15
X5 w_0_0# a_200_252# a_230_525# w_0_0# sky130_fd_pr__pfet_01v8 ad=0.0588 pd=0.7 as=0.0588 ps=0.7 w=0.42 l=0.15
X6 a_230_525# a_200_252# w_0_0# w_0_0# sky130_fd_pr__pfet_01v8 ad=0.0588 pd=0.7 as=0.0588 ps=0.7 w=0.42 l=0.15
X7 a_230_525# a_200_252# w_0_0# w_0_0# sky130_fd_pr__pfet_01v8 ad=0.0588 pd=0.7 as=0.0588 ps=0.7 w=0.42 l=0.15
C0 w_0_0# a_200_252# 2.48786f
C1 a_230_525# a_200_252# 0.40492f
C2 a_230_525# w_0_0# 3.00516f
C3 a_230_525# VSUBS 0.161483f
C4 a_200_252# VSUBS 0.320881f
C5 w_0_0# VSUBS 5.15626f
.ends

.subckt NMOS_4T_34206428_X9_Y1_1774869424 a_147_525# a_200_252# a_241_1232# a_230_525#
X0 a_230_525# a_200_252# a_147_525# a_241_1232# sky130_fd_pr__nfet_01v8 ad=0.0588 pd=0.7 as=0.0588 ps=0.7 w=0.42 l=0.15
X1 a_230_525# a_200_252# a_147_525# a_241_1232# sky130_fd_pr__nfet_01v8 ad=0.0588 pd=0.7 as=0.0588 ps=0.7 w=0.42 l=0.15
X2 a_147_525# a_200_252# a_230_525# a_241_1232# sky130_fd_pr__nfet_01v8 ad=0.0588 pd=0.7 as=0.0588 ps=0.7 w=0.42 l=0.15
X3 a_230_525# a_200_252# a_147_525# a_241_1232# sky130_fd_pr__nfet_01v8 ad=0.0588 pd=0.7 as=0.0588 ps=0.7 w=0.42 l=0.15
X4 a_230_525# a_200_252# a_147_525# a_241_1232# sky130_fd_pr__nfet_01v8 ad=0.0588 pd=0.7 as=0.0588 ps=0.7 w=0.42 l=0.15
X5 a_147_525# a_200_252# a_230_525# a_241_1232# sky130_fd_pr__nfet_01v8 ad=0.0588 pd=0.7 as=0.0588 ps=0.7 w=0.42 l=0.15
X6 a_230_525# a_200_252# a_147_525# a_241_1232# sky130_fd_pr__nfet_01v8 ad=0.0588 pd=0.7 as=0.0588 ps=0.7 w=0.42 l=0.15
X7 a_147_525# a_200_252# a_230_525# a_241_1232# sky130_fd_pr__nfet_01v8 ad=0.0588 pd=0.7 as=0.0588 ps=0.7 w=0.42 l=0.15
X8 a_147_525# a_200_252# a_230_525# a_241_1232# sky130_fd_pr__nfet_01v8 ad=0.0588 pd=0.7 as=0.0588 ps=0.7 w=0.42 l=0.15
X9 a_230_525# a_200_252# a_147_525# a_241_1232# sky130_fd_pr__nfet_01v8 ad=0.0588 pd=0.7 as=0.0588 ps=0.7 w=0.42 l=0.15
X10 a_230_525# a_200_252# a_147_525# a_241_1232# sky130_fd_pr__nfet_01v8 ad=0.0588 pd=0.7 as=0.0588 ps=0.7 w=0.42 l=0.15
X11 a_147_525# a_200_252# a_230_525# a_241_1232# sky130_fd_pr__nfet_01v8 ad=0.1113 pd=1.37 as=0.0588 ps=0.7 w=0.42 l=0.15
X12 a_230_525# a_200_252# a_147_525# a_241_1232# sky130_fd_pr__nfet_01v8 ad=0.0588 pd=0.7 as=0.0588 ps=0.7 w=0.42 l=0.15
X13 a_147_525# a_200_252# a_230_525# a_241_1232# sky130_fd_pr__nfet_01v8 ad=0.0588 pd=0.7 as=0.0588 ps=0.7 w=0.42 l=0.15
X14 a_147_525# a_200_252# a_230_525# a_241_1232# sky130_fd_pr__nfet_01v8 ad=0.0588 pd=0.7 as=0.0588 ps=0.7 w=0.42 l=0.15
X15 a_230_525# a_200_252# a_147_525# a_241_1232# sky130_fd_pr__nfet_01v8 ad=0.0588 pd=0.7 as=0.1113 ps=1.37 w=0.42 l=0.15
X16 a_147_525# a_200_252# a_230_525# a_241_1232# sky130_fd_pr__nfet_01v8 ad=0.0588 pd=0.7 as=0.0588 ps=0.7 w=0.42 l=0.15
X17 a_147_525# a_200_252# a_230_525# a_241_1232# sky130_fd_pr__nfet_01v8 ad=0.0588 pd=0.7 as=0.0588 ps=0.7 w=0.42 l=0.15
C0 a_200_252# a_147_525# 0.915725f
C1 a_230_525# a_147_525# 6.26781f
C2 a_230_525# a_200_252# 0.911582f
C3 a_230_525# a_241_1232# 0.787776f
C4 a_147_525# a_241_1232# 0.980622f
C5 a_200_252# a_241_1232# 4.77597f
.ends

.subckt PMOS_4T_68898473_X1_Y1_1774869425 a_147_525# a_200_252# w_0_0# a_230_525#
+ VSUBS
X0 a_230_525# a_200_252# a_147_525# w_0_0# sky130_fd_pr__pfet_01v8 ad=0.0588 pd=0.7 as=0.1113 ps=1.37 w=0.42 l=0.15
X1 a_147_525# a_200_252# a_230_525# w_0_0# sky130_fd_pr__pfet_01v8 ad=0.1113 pd=1.37 as=0.0588 ps=0.7 w=0.42 l=0.15
C0 a_230_525# w_0_0# 0.066352f
C1 a_147_525# a_230_525# 0.699652f
C2 w_0_0# a_200_252# 0.639343f
C3 a_147_525# a_200_252# 0.102008f
C4 a_147_525# w_0_0# 0.196586f
C5 a_230_525# a_200_252# 0.105665f
C6 a_230_525# VSUBS 0.07188f
C7 a_147_525# VSUBS 0.251082f
C8 a_200_252# VSUBS 0.199601f
C9 w_0_0# VSUBS 2.44474f
.ends

.subckt SCM_NMOS_19423653_X5_Y1_1774869427 a_402_525# a_147_525# a_200_252#
X0 a_402_525# a_200_252# a_147_525# a_147_525# sky130_fd_pr__nfet_01v8 ad=0.0588 pd=0.7 as=0.0588 ps=0.7 w=0.42 l=0.15
X1 a_402_525# a_200_252# a_147_525# a_147_525# sky130_fd_pr__nfet_01v8 ad=0.0588 pd=0.7 as=0.0588 ps=0.7 w=0.42 l=0.15
X2 a_147_525# a_200_252# a_402_525# a_147_525# sky130_fd_pr__nfet_01v8 ad=0.0588 pd=0.7 as=0.0588 ps=0.7 w=0.42 l=0.15
X3 a_147_525# a_200_252# a_402_525# a_147_525# sky130_fd_pr__nfet_01v8 ad=0.1113 pd=1.37 as=0.0588 ps=0.7 w=0.42 l=0.15
X4 a_402_525# a_200_252# a_147_525# a_147_525# sky130_fd_pr__nfet_01v8 ad=0.0588 pd=0.7 as=0.0588 ps=0.7 w=0.42 l=0.15
X5 a_402_525# a_200_252# a_147_525# a_147_525# sky130_fd_pr__nfet_01v8 ad=0.0588 pd=0.7 as=0.0588 ps=0.7 w=0.42 l=0.15
X6 a_147_525# a_200_252# a_402_525# a_147_525# sky130_fd_pr__nfet_01v8 ad=0.0588 pd=0.7 as=0.0588 ps=0.7 w=0.42 l=0.15
X7 a_200_252# a_200_252# a_147_525# a_147_525# sky130_fd_pr__nfet_01v8 ad=0.0588 pd=0.7 as=0.0588 ps=0.7 w=0.42 l=0.15
X8 a_147_525# a_200_252# a_402_525# a_147_525# sky130_fd_pr__nfet_01v8 ad=0.0588 pd=0.7 as=0.0588 ps=0.7 w=0.42 l=0.15
X9 a_147_525# a_200_252# a_402_525# a_147_525# sky130_fd_pr__nfet_01v8 ad=0.0588 pd=0.7 as=0.0588 ps=0.7 w=0.42 l=0.15
X10 a_200_252# a_200_252# a_147_525# a_147_525# sky130_fd_pr__nfet_01v8 ad=0.0588 pd=0.7 as=0.0588 ps=0.7 w=0.42 l=0.15
X11 a_200_252# a_200_252# a_147_525# a_147_525# sky130_fd_pr__nfet_01v8 ad=0.0588 pd=0.7 as=0.0588 ps=0.7 w=0.42 l=0.15
X12 a_147_525# a_200_252# a_200_252# a_147_525# sky130_fd_pr__nfet_01v8 ad=0.0588 pd=0.7 as=0.0588 ps=0.7 w=0.42 l=0.15
X13 a_200_252# a_200_252# a_147_525# a_147_525# sky130_fd_pr__nfet_01v8 ad=0.0588 pd=0.7 as=0.0588 ps=0.7 w=0.42 l=0.15
X14 a_147_525# a_200_252# a_200_252# a_147_525# sky130_fd_pr__nfet_01v8 ad=0.0588 pd=0.7 as=0.0588 ps=0.7 w=0.42 l=0.15
X15 a_147_525# a_200_252# a_200_252# a_147_525# sky130_fd_pr__nfet_01v8 ad=0.0588 pd=0.7 as=0.0588 ps=0.7 w=0.42 l=0.15
X16 a_200_252# a_200_252# a_147_525# a_147_525# sky130_fd_pr__nfet_01v8 ad=0.0588 pd=0.7 as=0.1113 ps=1.37 w=0.42 l=0.15
X17 a_147_525# a_200_252# a_200_252# a_147_525# sky130_fd_pr__nfet_01v8 ad=0.0588 pd=0.7 as=0.0588 ps=0.7 w=0.42 l=0.15
X18 a_402_525# a_200_252# a_147_525# a_147_525# sky130_fd_pr__nfet_01v8 ad=0.0588 pd=0.7 as=0.0588 ps=0.7 w=0.42 l=0.15
X19 a_147_525# a_200_252# a_200_252# a_147_525# sky130_fd_pr__nfet_01v8 ad=0.0588 pd=0.7 as=0.0588 ps=0.7 w=0.42 l=0.15
C0 a_200_252# a_402_525# 1.42875f
C1 a_402_525# a_147_525# 4.30981f
C2 a_200_252# a_147_525# 10.64f
.ends

.subckt TELESCOPIC_OTA_0 IB VCN VOUT VIP VIN VCP VSS VDD
XNMOS_4T_14241495_X2_Y1_1774869423_0 m1_688_3164# VIN VSS m1_570_1652# NMOS_4T_14241495_X2_Y1_1774869423
XNMOS_4T_14241495_X2_Y1_1774869423_1 m1_688_3164# VIP VSS m1_3150_1652# NMOS_4T_14241495_X2_Y1_1774869423
XPMOS_S_70514696_X4_Y1_1774869426_0 m1_2634_560# VDD li_2383_1327# VSS PMOS_S_70514696_X4_Y1_1774869426
XPMOS_S_70514696_X4_Y1_1774869426_1 m1_2634_560# VDD li_1351_1327# VSS PMOS_S_70514696_X4_Y1_1774869426
XNMOS_4T_34206428_X9_Y1_1774869424_0 m1_570_1652# VCN VSS VOUT NMOS_4T_34206428_X9_Y1_1774869424
XNMOS_4T_34206428_X9_Y1_1774869424_1 m1_3150_1652# VCN VSS m1_2634_560# NMOS_4T_34206428_X9_Y1_1774869424
XPMOS_4T_68898473_X1_Y1_1774869425_0 li_2383_1327# VCP VDD VOUT VSS PMOS_4T_68898473_X1_Y1_1774869425
XPMOS_4T_68898473_X1_Y1_1774869425_1 li_1351_1327# VCP VDD m1_2634_560# VSS PMOS_4T_68898473_X1_Y1_1774869425
XSCM_NMOS_19423653_X5_Y1_1774869427_0 m1_688_3164# VSS IB SCM_NMOS_19423653_X5_Y1_1774869427
R0 VIN.n1 VIN.t1 568.582
R1 VIN.n1 VIN.t0 568.582
R2 VIN.n0 VIN.t3 568.582
R3 VIN.n0 VIN.t2 568.582
R4 VIN VIN.n1 161.493
R5 VIN VIN.n0 161.493
R6 VSS.n45 VSS.n44 146708
R7 VSS.n25 VSS.n24 1179.3
R8 VSS.n23 VSS.n22 1179.3
R9 VSS.n21 VSS.n15 1179.3
R10 VSS.n20 VSS.n19 1179.3
R11 VSS.n18 VSS.n17 1179.3
R12 VSS.n2 VSS.n1 1179.3
R13 VSS.n48 VSS.n47 1179.3
R14 VSS.n34 VSS.n7 1179.3
R15 VSS.n33 VSS.n32 1179.3
R16 VSS.n31 VSS.n8 1179.3
R17 VSS.n30 VSS.n29 1179.3
R18 VSS.n28 VSS.n12 1179.3
R19 VSS.n27 VSS.n26 1179.3
R20 VSS.n43 VSS.n42 1179.3
R21 VSS.n41 VSS.n4 1179.3
R22 VSS.n40 VSS.n39 1179.3
R23 VSS.n38 VSS.n5 1179.3
R24 VSS.n37 VSS.n36 1179.3
R25 VSS.n7 VSS.n6 1179.3
R26 VSS.n32 VSS.n11 1179.3
R27 VSS.n10 VSS.n3 546.721
R28 VSS.n16 VSS.n0 546.393
R29 VSS.n44 VSS.n43 533.053
R30 VSS.n35 VSS.n34 533.053
R31 VSS.n27 VSS.n13 533.053
R32 VSS.n24 VSS.n14 533.053
R33 VSS.n47 VSS.n46 488.43
R34 VSS.n42 VSS.n41 252.773
R35 VSS.n41 VSS.n40 252.773
R36 VSS.n40 VSS.n5 252.773
R37 VSS.n36 VSS.n7 252.773
R38 VSS.n32 VSS.n7 252.773
R39 VSS.n32 VSS.n31 252.773
R40 VSS.n31 VSS.n30 252.773
R41 VSS.n30 VSS.n12 252.773
R42 VSS.n26 VSS.n25 252.773
R43 VSS.n22 VSS.n21 252.773
R44 VSS.n21 VSS.n20 252.773
R45 VSS.n20 VSS.n17 252.773
R46 VSS.n47 VSS.n2 252.773
R47 VSS.n46 VSS.n45 232.148
R48 VSS.n44 VSS.n3 228.292
R49 VSS.n35 VSS.n5 114.174
R50 VSS.n14 VSS.n12 114.174
R51 VSS.n22 VSS.n13 114.174
R52 VSS.n17 VSS.n16 114.174
R53 VSS.n42 VSS.n3 114.156
R54 VSS.n26 VSS.n14 114.136
R55 VSS.n36 VSS.n35 114.136
R56 VSS.n25 VSS.n13 114.136
R57 VSS.n16 VSS.n2 114.136
R58 VSS.n49 VSS.n48 10.348
R59 VSS.n11 VSS.n10 10.348
R60 VSS VSS.n8 8.6255
R61 VSS.n9 VSS 5.098
R62 VSS VSS.n49 3.66194
R63 VSS.n9 VSS.n0 0.455225
R64 VSS.n34 VSS.n33 0.384429
R65 VSS.n33 VSS.n8 0.384429
R66 VSS.n29 VSS.n8 0.384429
R67 VSS.n29 VSS.n28 0.384429
R68 VSS.n28 VSS.n27 0.384429
R69 VSS.n24 VSS.n23 0.384429
R70 VSS.n23 VSS.n15 0.384429
R71 VSS.n19 VSS.n15 0.384429
R72 VSS.n19 VSS.n18 0.384429
R73 VSS.n18 VSS.n1 0.384429
R74 VSS.n48 VSS.n1 0.384429
R75 VSS.n43 VSS.n4 0.384429
R76 VSS.n39 VSS.n4 0.384429
R77 VSS.n39 VSS.n38 0.384429
R78 VSS.n38 VSS.n37 0.384429
R79 VSS.n37 VSS.n6 0.384429
R80 VSS.n11 VSS.n6 0.384429
R81 VSS.n10 VSS.n9 0.051025
R82 VSS.n49 VSS.n0 0.051025
R83 VIP.n1 VIP.t2 568.582
R84 VIP.n1 VIP.t3 568.582
R85 VIP.n0 VIP.t0 568.582
R86 VIP.n0 VIP.t1 568.582
R87 VIP VIP.n1 161.493
R88 VIP VIP.n0 161.493
R89 VDD.n11 VDD.n10 597.71
R90 VDD.n7 VDD.n6 379.685
R91 VDD.n8 VDD.n7 379.3
R92 VDD.n10 VDD.n0 166.097
R93 VDD.n10 VDD.n9 128.328
R94 VDD.n2 VDD.n1 54.0349
R95 VDD.n5 VDD.n4 54.0349
R96 VDD.n4 VDD.n3 54.0349
R97 VDD.n9 VDD.n8 27.0177
R98 VDD.n8 VDD.n1 27.0177
R99 VDD.n6 VDD.n2 27.0177
R100 VDD.n6 VDD.n5 27.0177
R101 VDD.n11 VDD 13.1746
R102 VDD.n0 VDD 4.59425
R103 VDD VDD.n11 4.09151
R104 VDD.n7 VDD.n0 0.384429
R105 VCN.n26 VCN.t15 568.582
R106 VCN.n26 VCN.t16 568.582
R107 VCN.n27 VCN.t3 568.582
R108 VCN.n27 VCN.t7 568.582
R109 VCN.n29 VCN.t12 568.582
R110 VCN.n29 VCN.t17 568.582
R111 VCN.n31 VCN.t4 568.582
R112 VCN.n31 VCN.t8 568.582
R113 VCN.n25 VCN.t9 568.582
R114 VCN.n25 VCN.t13 568.582
R115 VCN.n23 VCN.t0 568.582
R116 VCN.n23 VCN.t5 568.582
R117 VCN.n21 VCN.t10 568.582
R118 VCN.n21 VCN.t14 568.582
R119 VCN.n19 VCN.t1 568.582
R120 VCN.n19 VCN.t2 568.582
R121 VCN.n17 VCN.t6 568.582
R122 VCN.n17 VCN.t11 568.582
R123 VCN.n15 VCN.t29 568.582
R124 VCN.n15 VCN.t24 568.582
R125 VCN.n13 VCN.t20 568.582
R126 VCN.n13 VCN.t19 568.582
R127 VCN.n11 VCN.t32 568.582
R128 VCN.n11 VCN.t28 568.582
R129 VCN.n9 VCN.t23 568.582
R130 VCN.n9 VCN.t18 568.582
R131 VCN.n7 VCN.t31 568.582
R132 VCN.n7 VCN.t27 568.582
R133 VCN.n5 VCN.t26 568.582
R134 VCN.n5 VCN.t22 568.582
R135 VCN.n3 VCN.t35 568.582
R136 VCN.n3 VCN.t30 568.582
R137 VCN.n1 VCN.t25 568.582
R138 VCN.n1 VCN.t21 568.582
R139 VCN.n0 VCN.t34 568.582
R140 VCN.n0 VCN.t33 568.582
R141 VCN.n28 VCN.n26 161.685
R142 VCN.n2 VCN.n0 161.685
R143 VCN.n28 VCN.n27 161.3
R144 VCN.n30 VCN.n29 161.3
R145 VCN.n32 VCN.n31 161.3
R146 VCN VCN.n25 161.3
R147 VCN.n24 VCN.n23 161.3
R148 VCN.n22 VCN.n21 161.3
R149 VCN.n20 VCN.n19 161.3
R150 VCN.n18 VCN.n17 161.3
R151 VCN.n16 VCN.n15 161.3
R152 VCN.n14 VCN.n13 161.3
R153 VCN.n12 VCN.n11 161.3
R154 VCN.n10 VCN.n9 161.3
R155 VCN.n8 VCN.n7 161.3
R156 VCN.n6 VCN.n5 161.3
R157 VCN.n4 VCN.n3 161.3
R158 VCN.n2 VCN.n1 161.3
R159 VCN.n18 VCN.n16 1.15229
R160 VCN.n4 VCN.n2 0.384429
R161 VCN.n6 VCN.n4 0.384429
R162 VCN.n8 VCN.n6 0.384429
R163 VCN.n10 VCN.n8 0.384429
R164 VCN.n12 VCN.n10 0.384429
R165 VCN.n14 VCN.n12 0.384429
R166 VCN.n16 VCN.n14 0.384429
R167 VCN.n20 VCN.n18 0.384429
R168 VCN.n22 VCN.n20 0.384429
R169 VCN.n24 VCN.n22 0.384429
R170 VCN VCN.n24 0.384429
R171 VCN VCN.n32 0.384429
R172 VCN.n32 VCN.n30 0.384429
R173 VCN.n30 VCN.n28 0.384429
R174 VCP.n1 VCP.t2 568.582
R175 VCP.n1 VCP.t3 568.582
R176 VCP.n0 VCP.t1 568.582
R177 VCP.n0 VCP.t0 568.582
R178 VCP VCP.n0 162.261
R179 VCP VCP.n1 161.493
R180 IB.n10 IB.t4 568.582
R181 IB.n10 IB.t2 568.582
R182 IB.n11 IB.t24 568.582
R183 IB.n11 IB.t27 568.582
R184 IB.n13 IB.t10 568.582
R185 IB.n13 IB.t0 568.582
R186 IB.n15 IB.t25 568.582
R187 IB.n15 IB.t28 568.582
R188 IB.n9 IB.t16 568.582
R189 IB.n9 IB.t8 568.582
R190 IB.n7 IB.t20 568.582
R191 IB.n7 IB.t26 568.582
R192 IB.n5 IB.t14 568.582
R193 IB.n5 IB.t6 568.582
R194 IB.n3 IB.t21 568.582
R195 IB.n3 IB.t22 568.582
R196 IB.n1 IB.t18 568.582
R197 IB.n1 IB.t12 568.582
R198 IB.n0 IB.t29 568.582
R199 IB.n0 IB.t23 568.582
R200 IB.n24 IB.n22 316.413
R201 IB.n20 IB.n18 316.413
R202 IB.n24 IB.n23 315.644
R203 IB.n25 IB.n21 315.644
R204 IB.n20 IB.n19 315.644
R205 IB.n12 IB.n10 161.685
R206 IB.n2 IB.n0 161.685
R207 IB.n12 IB.n11 161.3
R208 IB.n14 IB.n13 161.3
R209 IB.n16 IB.n15 161.3
R210 IB.n17 IB.n9 161.3
R211 IB.n8 IB.n7 161.3
R212 IB.n6 IB.n5 161.3
R213 IB.n4 IB.n3 161.3
R214 IB.n2 IB.n1 161.3
R215 IB.n22 IB.t3 40.0005
R216 IB.n22 IB.t5 40.0005
R217 IB.n23 IB.t1 40.0005
R218 IB.n23 IB.t11 40.0005
R219 IB.n21 IB.t9 40.0005
R220 IB.n21 IB.t17 40.0005
R221 IB.n19 IB.t7 40.0005
R222 IB.n19 IB.t15 40.0005
R223 IB.n18 IB.t13 40.0005
R224 IB.n18 IB.t19 40.0005
R225 IB IB.n17 5.438
R226 IB IB.n25 5.438
R227 IB.n25 IB.n20 0.768357
R228 IB.n25 IB.n24 0.768357
R229 IB.n4 IB.n2 0.384429
R230 IB.n6 IB.n4 0.384429
R231 IB.n8 IB.n6 0.384429
R232 IB.n17 IB.n8 0.384429
R233 IB.n17 IB.n16 0.384429
R234 IB.n16 IB.n14 0.384429
R235 IB.n14 IB.n12 0.384429
C0 m1_3150_1652# VIP 6.93e-19
C1 IB VOUT 6.74e-20
C2 VOUT li_1351_1327# 0.333435f
C3 VOUT m1_688_3164# 5e-20
C4 VDD VIN 0.030857f
C5 m1_3150_1652# li_2383_1327# 0.028965f
C6 m1_570_1652# VOUT 0.091057f
C7 VOUT VCN 9.14e-19
C8 m1_2634_560# m1_3150_1652# 0.138085f
C9 VCP m1_3150_1652# 1.8e-19
C10 VDD m1_3150_1652# 0.167918f
C11 VDD VIP 0.032885f
C12 m1_2634_560# li_2383_1327# 0.404415f
C13 IB m1_688_3164# 0.113309f
C14 VCP li_2383_1327# 0.001245f
C15 VDD li_2383_1327# 0.34312f
C16 VCP m1_2634_560# 0.153113f
C17 m1_2634_560# VDD 1.162968f
C18 VOUT m1_3150_1652# 3.06e-19
C19 VCP VDD 0.192839f
C20 m1_570_1652# IB 0.009673f
C21 IB VCN 0.046608f
C22 m1_570_1652# li_1351_1327# 0.028965f
C23 VCN li_1351_1327# 0.002334f
C24 m1_570_1652# m1_688_3164# 0.012535f
C25 VCN m1_688_3164# 0.003295f
C26 IB VIN 0.043196f
C27 VOUT li_2383_1327# 0.014213f
C28 VOUT m1_2634_560# 0.284738f
C29 m1_570_1652# VCN 0.147221f
C30 VCP VOUT 0.009179f
C31 VOUT VDD 0.242894f
C32 m1_570_1652# VIN 6.93e-19
C33 IB m1_3150_1652# 0.004369f
C34 VIN VCN 0.003655f
C35 IB VIP 0.041045f
C36 m1_3150_1652# m1_688_3164# 0.012885f
C37 m1_570_1652# m1_3150_1652# 0.061097f
C38 m1_3150_1652# VCN 0.132677f
C39 VIP VCN 0.003655f
C40 li_2383_1327# li_1351_1327# 0.060882f
C41 IB m1_2634_560# 9.44e-19
C42 m1_2634_560# li_1351_1327# 0.46442f
C43 IB VDD 0.376387f
C44 m1_2634_560# m1_688_3164# 1e-19
C45 VCP li_1351_1327# -0.007977f
C46 VDD li_1351_1327# 0.200959f
C47 VDD m1_688_3164# 0.237795f
C48 VCN li_2383_1327# 0.002334f
C49 m1_570_1652# m1_2634_560# 0.038254f
C50 m1_2634_560# VCN 0.031411f
C51 VCP m1_570_1652# 1.8e-19
C52 m1_570_1652# VDD 0.10003f
C53 VCP VCN 0.00381f
C54 VDD VCN 0.189908f
C55 VCN VSS 10.230779f
C56 m1_2634_560# VSS 1.500821f
C57 VDD.n0 VSS 0.070877f
C58 VDD.n1 VSS 0.203208f
C59 VDD.n2 VSS 0.203208f
C60 VDD.n3 VSS 0.270943f
C61 VDD.n4 VSS 0.270943f
C62 VDD.n5 VSS 0.203208f
C63 VDD.n6 VSS 0.127886f
C64 VDD.n7 VSS 0.059623f
C65 VDD.n8 VSS 0.127859f
C66 VDD.n9 VSS 0.442817f
C67 VDD.n10 VSS 2.26212f
C68 VDD.n11 VSS 7.54887f
C69 IB VSS 10.588125f
C70 li_1351_1327# VSS 0.094262f
C71 VOUT VSS 7.430279f
C72 li_2383_1327# VSS 0.098488f
C73 VCP VSS 0.094634f
C74 VDD VSS 19.079538f
C75 m1_3150_1652# VSS 2.529012f
C76 m1_570_1652# VSS 2.215438f
C77 VIP VSS 1.331714f
C78 m1_688_3164# VSS 6.165547f
C79 VIN VSS 1.329157f
.ends
