* NGSPICE file created from TELESCOPIC_OTA_0.ext - technology: sky130A

.subckt NMOS_4T_14241495_X2_Y1_1774869423 a_147_525# a_200_252# a_241_1232# a_230_525#
X0 a_230_525# a_200_252# a_147_525# a_241_1232# sky130_fd_pr__nfet_01v8 ad=0.0588 pd=0.7 as=0.0588 ps=0.7 w=0.42 l=0.15 M=4
.ends

.subckt PMOS_S_70514696_X4_Y1_1774869426 a_200_252# w_0_0# a_230_525#
X0 w_0_0# a_200_252# a_230_525# w_0_0# sky130_fd_pr__pfet_01v8 ad=0.0588 pd=0.7 as=0.0588 ps=0.7 w=0.42 l=0.15 M=8
.ends

.subckt NMOS_4T_34206428_X9_Y1_1774869424 a_147_525# a_200_252# a_241_1232# a_230_525#
X0 a_230_525# a_200_252# a_147_525# a_241_1232# sky130_fd_pr__nfet_01v8 ad=0.0588 pd=0.7 as=0.0588 ps=0.7 w=0.42 l=0.15 M=18
.ends

.subckt PMOS_4T_68898473_X1_Y1_1774869425 a_147_525# a_200_252# w_0_0# a_230_525#
X0 a_230_525# a_200_252# a_147_525# w_0_0# sky130_fd_pr__pfet_01v8 ad=0.0588 pd=0.7 as=0.1113 ps=1.37 w=0.42 l=0.15 M=2
.ends

.subckt SCM_NMOS_19423653_X5_Y1_1774869427 a_402_525# a_147_525# a_200_252#
X0 a_402_525# a_200_252# a_147_525# a_147_525# sky130_fd_pr__nfet_01v8 ad=0.0588 pd=0.7 as=0.0588 ps=0.7 w=0.42 l=0.15 M=10
X1 a_200_252# a_200_252# a_147_525# a_147_525# sky130_fd_pr__nfet_01v8 ad=0.0588 pd=0.7 as=0.0588 ps=0.7 w=0.42 l=0.15 M=10
.ends

.subckt TELESCOPIC_OTA_0 IB VCN VOUT VIP VIN VCP VSS VDD
XNMOS_4T_14241495_X2_Y1_1774869423_0 m1_688_3164# VIN VSS m1_570_1652# NMOS_4T_14241495_X2_Y1_1774869423
XNMOS_4T_14241495_X2_Y1_1774869423_1 m1_688_3164# VIP VSS m1_3150_1652# NMOS_4T_14241495_X2_Y1_1774869423
XPMOS_S_70514696_X4_Y1_1774869426_0 m1_2634_560# VDD li_2383_1327# PMOS_S_70514696_X4_Y1_1774869426
XPMOS_S_70514696_X4_Y1_1774869426_1 m1_2634_560# VDD li_1351_1327# PMOS_S_70514696_X4_Y1_1774869426
XNMOS_4T_34206428_X9_Y1_1774869424_0 m1_570_1652# VCN VSS VOUT NMOS_4T_34206428_X9_Y1_1774869424
XNMOS_4T_34206428_X9_Y1_1774869424_1 m1_3150_1652# VCN VSS m1_2634_560# NMOS_4T_34206428_X9_Y1_1774869424
XPMOS_4T_68898473_X1_Y1_1774869425_0 li_2383_1327# VCP VDD VOUT PMOS_4T_68898473_X1_Y1_1774869425
XPMOS_4T_68898473_X1_Y1_1774869425_1 li_1351_1327# VCP VDD m1_2634_560# PMOS_4T_68898473_X1_Y1_1774869425
XSCM_NMOS_19423653_X5_Y1_1774869427_0 m1_688_3164# VSS IB SCM_NMOS_19423653_X5_Y1_1774869427
.ends
