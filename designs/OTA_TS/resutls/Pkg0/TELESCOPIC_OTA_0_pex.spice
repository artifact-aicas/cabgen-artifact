* NGSPICE file created from TELESCOPIC_OTA_0.ext - technology: sky130A

.subckt SCM_NMOS_15116351_X10_Y1_1774869217 a_402_420# a_200_252# a_147_420#
X0 a_147_420# a_200_252# a_402_420# a_147_420# sky130_fd_pr__nfet_01v8 ad=0.2058 pd=1.75 as=0.2058 ps=1.75 w=1.47 l=0.15
X1 a_147_420# a_200_252# a_200_252# a_147_420# sky130_fd_pr__nfet_01v8 ad=0.2058 pd=1.75 as=0.2058 ps=1.75 w=1.47 l=0.15
X2 a_402_420# a_200_252# a_147_420# a_147_420# sky130_fd_pr__nfet_01v8 ad=0.2058 pd=1.75 as=0.2058 ps=1.75 w=1.47 l=0.15
X3 a_200_252# a_200_252# a_147_420# a_147_420# sky130_fd_pr__nfet_01v8 ad=0.2058 pd=1.75 as=0.2058 ps=1.75 w=1.47 l=0.15
X4 a_147_420# a_200_252# a_200_252# a_147_420# sky130_fd_pr__nfet_01v8 ad=0.2058 pd=1.75 as=0.2058 ps=1.75 w=1.47 l=0.15
X5 a_147_420# a_200_252# a_402_420# a_147_420# sky130_fd_pr__nfet_01v8 ad=0.2058 pd=1.75 as=0.2058 ps=1.75 w=1.47 l=0.15
X6 a_402_420# a_200_252# a_147_420# a_147_420# sky130_fd_pr__nfet_01v8 ad=0.2058 pd=1.75 as=0.2058 ps=1.75 w=1.47 l=0.15
X7 a_147_420# a_200_252# a_200_252# a_147_420# sky130_fd_pr__nfet_01v8 ad=0.2058 pd=1.75 as=0.2058 ps=1.75 w=1.47 l=0.15
X8 a_147_420# a_200_252# a_200_252# a_147_420# sky130_fd_pr__nfet_01v8 ad=0.2058 pd=1.75 as=0.2058 ps=1.75 w=1.47 l=0.15
X9 a_402_420# a_200_252# a_147_420# a_147_420# sky130_fd_pr__nfet_01v8 ad=0.2058 pd=1.75 as=0.2058 ps=1.75 w=1.47 l=0.15
X10 a_147_420# a_200_252# a_402_420# a_147_420# sky130_fd_pr__nfet_01v8 ad=0.2058 pd=1.75 as=0.2058 ps=1.75 w=1.47 l=0.15
X11 a_147_420# a_200_252# a_200_252# a_147_420# sky130_fd_pr__nfet_01v8 ad=0.2058 pd=1.75 as=0.2058 ps=1.75 w=1.47 l=0.15
X12 a_200_252# a_200_252# a_147_420# a_147_420# sky130_fd_pr__nfet_01v8 ad=0.2058 pd=1.75 as=0.2058 ps=1.75 w=1.47 l=0.15
X13 a_147_420# a_200_252# a_200_252# a_147_420# sky130_fd_pr__nfet_01v8 ad=0.2058 pd=1.75 as=0.2058 ps=1.75 w=1.47 l=0.15
X14 a_200_252# a_200_252# a_147_420# a_147_420# sky130_fd_pr__nfet_01v8 ad=0.2058 pd=1.75 as=0.2058 ps=1.75 w=1.47 l=0.15
X15 a_147_420# a_200_252# a_402_420# a_147_420# sky130_fd_pr__nfet_01v8 ad=0.2058 pd=1.75 as=0.2058 ps=1.75 w=1.47 l=0.15
X16 a_200_252# a_200_252# a_147_420# a_147_420# sky130_fd_pr__nfet_01v8 ad=0.2058 pd=1.75 as=0.38955 ps=3.47 w=1.47 l=0.15
X17 a_402_420# a_200_252# a_147_420# a_147_420# sky130_fd_pr__nfet_01v8 ad=0.2058 pd=1.75 as=0.2058 ps=1.75 w=1.47 l=0.15
X18 a_147_420# a_200_252# a_200_252# a_147_420# sky130_fd_pr__nfet_01v8 ad=0.2058 pd=1.75 as=0.2058 ps=1.75 w=1.47 l=0.15
X19 a_147_420# a_200_252# a_402_420# a_147_420# sky130_fd_pr__nfet_01v8 ad=0.2058 pd=1.75 as=0.2058 ps=1.75 w=1.47 l=0.15
X20 a_200_252# a_200_252# a_147_420# a_147_420# sky130_fd_pr__nfet_01v8 ad=0.2058 pd=1.75 as=0.2058 ps=1.75 w=1.47 l=0.15
X21 a_147_420# a_200_252# a_402_420# a_147_420# sky130_fd_pr__nfet_01v8 ad=0.2058 pd=1.75 as=0.2058 ps=1.75 w=1.47 l=0.15
X22 a_402_420# a_200_252# a_147_420# a_147_420# sky130_fd_pr__nfet_01v8 ad=0.2058 pd=1.75 as=0.2058 ps=1.75 w=1.47 l=0.15
X23 a_402_420# a_200_252# a_147_420# a_147_420# sky130_fd_pr__nfet_01v8 ad=0.2058 pd=1.75 as=0.2058 ps=1.75 w=1.47 l=0.15
X24 a_402_420# a_200_252# a_147_420# a_147_420# sky130_fd_pr__nfet_01v8 ad=0.2058 pd=1.75 as=0.2058 ps=1.75 w=1.47 l=0.15
X25 a_147_420# a_200_252# a_200_252# a_147_420# sky130_fd_pr__nfet_01v8 ad=0.38955 pd=3.47 as=0.2058 ps=1.75 w=1.47 l=0.15
X26 a_147_420# a_200_252# a_200_252# a_147_420# sky130_fd_pr__nfet_01v8 ad=0.2058 pd=1.75 as=0.2058 ps=1.75 w=1.47 l=0.15
X27 a_200_252# a_200_252# a_147_420# a_147_420# sky130_fd_pr__nfet_01v8 ad=0.2058 pd=1.75 as=0.2058 ps=1.75 w=1.47 l=0.15
X28 a_147_420# a_200_252# a_402_420# a_147_420# sky130_fd_pr__nfet_01v8 ad=0.2058 pd=1.75 as=0.2058 ps=1.75 w=1.47 l=0.15
X29 a_402_420# a_200_252# a_147_420# a_147_420# sky130_fd_pr__nfet_01v8 ad=0.2058 pd=1.75 as=0.2058 ps=1.75 w=1.47 l=0.15
X30 a_147_420# a_200_252# a_200_252# a_147_420# sky130_fd_pr__nfet_01v8 ad=0.2058 pd=1.75 as=0.2058 ps=1.75 w=1.47 l=0.15
X31 a_200_252# a_200_252# a_147_420# a_147_420# sky130_fd_pr__nfet_01v8 ad=0.2058 pd=1.75 as=0.2058 ps=1.75 w=1.47 l=0.15
X32 a_200_252# a_200_252# a_147_420# a_147_420# sky130_fd_pr__nfet_01v8 ad=0.2058 pd=1.75 as=0.2058 ps=1.75 w=1.47 l=0.15
X33 a_147_420# a_200_252# a_402_420# a_147_420# sky130_fd_pr__nfet_01v8 ad=0.2058 pd=1.75 as=0.2058 ps=1.75 w=1.47 l=0.15
X34 a_402_420# a_200_252# a_147_420# a_147_420# sky130_fd_pr__nfet_01v8 ad=0.2058 pd=1.75 as=0.2058 ps=1.75 w=1.47 l=0.15
X35 a_147_420# a_200_252# a_402_420# a_147_420# sky130_fd_pr__nfet_01v8 ad=0.2058 pd=1.75 as=0.2058 ps=1.75 w=1.47 l=0.15
X36 a_200_252# a_200_252# a_147_420# a_147_420# sky130_fd_pr__nfet_01v8 ad=0.2058 pd=1.75 as=0.2058 ps=1.75 w=1.47 l=0.15
X37 a_402_420# a_200_252# a_147_420# a_147_420# sky130_fd_pr__nfet_01v8 ad=0.2058 pd=1.75 as=0.2058 ps=1.75 w=1.47 l=0.15
X38 a_200_252# a_200_252# a_147_420# a_147_420# sky130_fd_pr__nfet_01v8 ad=0.2058 pd=1.75 as=0.2058 ps=1.75 w=1.47 l=0.15
X39 a_147_420# a_200_252# a_402_420# a_147_420# sky130_fd_pr__nfet_01v8 ad=0.2058 pd=1.75 as=0.2058 ps=1.75 w=1.47 l=0.15
C0 a_402_420# a_200_252# 2.9455f
C1 a_402_420# a_147_420# 8.47005f
C2 a_200_252# a_147_420# 17.7892f
.ends

.subckt NMOS_4T_47642139_X3_Y1_1774869213 a_230_420# a_200_252# a_147_420# a_241_1232#
X0 a_147_420# a_200_252# a_230_420# a_241_1232# sky130_fd_pr__nfet_01v8 ad=0.2058 pd=1.75 as=0.2058 ps=1.75 w=1.47 l=0.15
X1 a_230_420# a_200_252# a_147_420# a_241_1232# sky130_fd_pr__nfet_01v8 ad=0.2058 pd=1.75 as=0.2058 ps=1.75 w=1.47 l=0.15
X2 a_230_420# a_200_252# a_147_420# a_241_1232# sky130_fd_pr__nfet_01v8 ad=0.2058 pd=1.75 as=0.38955 ps=3.47 w=1.47 l=0.15
X3 a_147_420# a_200_252# a_230_420# a_241_1232# sky130_fd_pr__nfet_01v8 ad=0.2058 pd=1.75 as=0.2058 ps=1.75 w=1.47 l=0.15
X4 a_147_420# a_200_252# a_230_420# a_241_1232# sky130_fd_pr__nfet_01v8 ad=0.38955 pd=3.47 as=0.2058 ps=1.75 w=1.47 l=0.15
X5 a_230_420# a_200_252# a_147_420# a_241_1232# sky130_fd_pr__nfet_01v8 ad=0.2058 pd=1.75 as=0.2058 ps=1.75 w=1.47 l=0.15
C0 a_147_420# a_230_420# 2.05269f
C1 a_147_420# a_200_252# 0.254211f
C2 a_230_420# a_200_252# 0.260594f
C3 a_230_420# a_241_1232# 0.2281f
C4 a_147_420# a_241_1232# 0.545616f
C5 a_200_252# a_241_1232# 1.36478f
.ends

.subckt PMOS_4T_843553_X7_Y1_1774869215 a_230_420# a_200_252# a_147_420# w_0_0# VSUBS
X0 a_230_420# a_200_252# a_147_420# w_0_0# sky130_fd_pr__pfet_01v8 ad=0.2058 pd=1.75 as=0.2058 ps=1.75 w=1.47 l=0.15
X1 a_147_420# a_200_252# a_230_420# w_0_0# sky130_fd_pr__pfet_01v8 ad=0.2058 pd=1.75 as=0.2058 ps=1.75 w=1.47 l=0.15
X2 a_147_420# a_200_252# a_230_420# w_0_0# sky130_fd_pr__pfet_01v8 ad=0.38955 pd=3.47 as=0.2058 ps=1.75 w=1.47 l=0.15
X3 a_230_420# a_200_252# a_147_420# w_0_0# sky130_fd_pr__pfet_01v8 ad=0.2058 pd=1.75 as=0.38955 ps=3.47 w=1.47 l=0.15
X4 a_147_420# a_200_252# a_230_420# w_0_0# sky130_fd_pr__pfet_01v8 ad=0.2058 pd=1.75 as=0.2058 ps=1.75 w=1.47 l=0.15
X5 a_147_420# a_200_252# a_230_420# w_0_0# sky130_fd_pr__pfet_01v8 ad=0.2058 pd=1.75 as=0.2058 ps=1.75 w=1.47 l=0.15
X6 a_230_420# a_200_252# a_147_420# w_0_0# sky130_fd_pr__pfet_01v8 ad=0.2058 pd=1.75 as=0.2058 ps=1.75 w=1.47 l=0.15
X7 a_230_420# a_200_252# a_147_420# w_0_0# sky130_fd_pr__pfet_01v8 ad=0.2058 pd=1.75 as=0.2058 ps=1.75 w=1.47 l=0.15
X8 a_230_420# a_200_252# a_147_420# w_0_0# sky130_fd_pr__pfet_01v8 ad=0.2058 pd=1.75 as=0.2058 ps=1.75 w=1.47 l=0.15
X9 a_147_420# a_200_252# a_230_420# w_0_0# sky130_fd_pr__pfet_01v8 ad=0.2058 pd=1.75 as=0.2058 ps=1.75 w=1.47 l=0.15
X10 a_147_420# a_200_252# a_230_420# w_0_0# sky130_fd_pr__pfet_01v8 ad=0.2058 pd=1.75 as=0.2058 ps=1.75 w=1.47 l=0.15
X11 a_147_420# a_200_252# a_230_420# w_0_0# sky130_fd_pr__pfet_01v8 ad=0.2058 pd=1.75 as=0.2058 ps=1.75 w=1.47 l=0.15
X12 a_230_420# a_200_252# a_147_420# w_0_0# sky130_fd_pr__pfet_01v8 ad=0.2058 pd=1.75 as=0.2058 ps=1.75 w=1.47 l=0.15
X13 a_230_420# a_200_252# a_147_420# w_0_0# sky130_fd_pr__pfet_01v8 ad=0.2058 pd=1.75 as=0.2058 ps=1.75 w=1.47 l=0.15
C0 a_200_252# a_230_420# 0.608597f
C1 a_147_420# a_230_420# 4.87558f
C2 a_230_420# w_0_0# 0.250157f
C3 a_200_252# a_147_420# 0.609047f
C4 a_200_252# w_0_0# 2.49666f
C5 a_147_420# w_0_0# 0.434785f
C6 a_230_420# VSUBS 0.285614f
C7 a_147_420# VSUBS 0.313681f
C8 a_200_252# VSUBS 0.41245f
C9 w_0_0# VSUBS 7.2786f
.ends

.subckt NMOS_4T_91499272_X1_Y1_1774869214 a_230_420# a_200_252# a_147_420# a_241_1232#
X0 a_230_420# a_200_252# a_147_420# a_241_1232# sky130_fd_pr__nfet_01v8 ad=0.2058 pd=1.75 as=0.38955 ps=3.47 w=1.47 l=0.15
X1 a_147_420# a_200_252# a_230_420# a_241_1232# sky130_fd_pr__nfet_01v8 ad=0.38955 pd=3.47 as=0.2058 ps=1.75 w=1.47 l=0.15
C0 a_147_420# a_230_420# 0.701788f
C1 a_147_420# a_200_252# 0.087538f
C2 a_230_420# a_200_252# 0.091334f
C3 a_230_420# a_241_1232# 0.127325f
C4 a_147_420# a_241_1232# 0.422841f
C5 a_200_252# a_241_1232# 0.649444f
.ends

.subckt PMOS_S_44280068_X2_Y1_1774869216 a_230_420# a_200_252# w_0_0# VSUBS
X0 a_230_420# a_200_252# w_0_0# w_0_0# sky130_fd_pr__pfet_01v8 ad=0.2058 pd=1.75 as=0.38955 ps=3.47 w=1.47 l=0.15
X1 w_0_0# a_200_252# a_230_420# w_0_0# sky130_fd_pr__pfet_01v8 ad=0.2058 pd=1.75 as=0.2058 ps=1.75 w=1.47 l=0.15
X2 a_230_420# a_200_252# w_0_0# w_0_0# sky130_fd_pr__pfet_01v8 ad=0.2058 pd=1.75 as=0.2058 ps=1.75 w=1.47 l=0.15
X3 w_0_0# a_200_252# a_230_420# w_0_0# sky130_fd_pr__pfet_01v8 ad=0.38955 pd=3.47 as=0.2058 ps=1.75 w=1.47 l=0.15
C0 a_200_252# a_230_420# 0.173593f
C1 a_200_252# w_0_0# 1.02806f
C2 a_230_420# w_0_0# 1.46917f
C3 a_230_420# VSUBS 0.078728f
C4 a_200_252# VSUBS 0.205611f
C5 w_0_0# VSUBS 3.68568f
.ends

.subckt TELESCOPIC_OTA_0 IB VCN VOUT VIP VIN VCP VSS VDD
XSCM_NMOS_15116351_X10_Y1_1774869217_0 m1_1860_1316# IB VSS SCM_NMOS_15116351_X10_Y1_1774869217
XNMOS_4T_47642139_X3_Y1_1774869213_0 m1_1688_2912# VIN m1_1860_1316# VSS NMOS_4T_47642139_X3_Y1_1774869213
XNMOS_4T_47642139_X3_Y1_1774869213_1 m1_2376_2912# VIP m1_1860_1316# VSS NMOS_4T_47642139_X3_Y1_1774869213
XPMOS_4T_843553_X7_Y1_1774869215_0 VOUT VCP m1_742_2912# VDD VSS PMOS_4T_843553_X7_Y1_1774869215
XPMOS_4T_843553_X7_Y1_1774869215_1 m1_3322_2072# VCP m1_3236_2912# VDD VSS PMOS_4T_843553_X7_Y1_1774869215
XNMOS_4T_91499272_X1_Y1_1774869214_1 m1_3322_2072# VCN m1_2376_2912# VSS NMOS_4T_91499272_X1_Y1_1774869214
XNMOS_4T_91499272_X1_Y1_1774869214_0 VOUT VCN m1_1688_2912# VSS NMOS_4T_91499272_X1_Y1_1774869214
XPMOS_S_44280068_X2_Y1_1774869216_0 m1_742_2912# m1_3322_2072# VDD VSS PMOS_S_44280068_X2_Y1_1774869216
XPMOS_S_44280068_X2_Y1_1774869216_1 m1_3236_2912# m1_3322_2072# VDD VSS PMOS_S_44280068_X2_Y1_1774869216
R0 IB.n86 IB.t20 573.581
R1 IB.n84 IB.t18 573.581
R2 IB.n91 IB.t54 573.581
R3 IB.n89 IB.t40 573.581
R4 IB.n97 IB.t44 573.581
R5 IB.n95 IB.t48 573.581
R6 IB.n103 IB.t6 573.581
R7 IB.n101 IB.t38 573.581
R8 IB.n109 IB.t36 573.581
R9 IB.n107 IB.t28 573.581
R10 IB.n115 IB.t52 573.581
R11 IB.n113 IB.t57 573.581
R12 IB.n121 IB.t43 573.581
R13 IB.n119 IB.t46 573.581
R14 IB.n127 IB.t10 573.581
R15 IB.n125 IB.t12 573.581
R16 IB.n133 IB.t2 573.581
R17 IB.n131 IB.t32 573.581
R18 IB.n81 IB.t47 573.581
R19 IB.n79 IB.t53 573.581
R20 IB.n75 IB.t58 573.581
R21 IB.n73 IB.t59 573.581
R22 IB.n69 IB.t0 573.581
R23 IB.n67 IB.t30 573.581
R24 IB.n63 IB.t16 573.581
R25 IB.n61 IB.t8 573.581
R26 IB.n57 IB.t41 573.581
R27 IB.n55 IB.t45 573.581
R28 IB.n51 IB.t50 573.581
R29 IB.n49 IB.t49 573.581
R30 IB.n45 IB.t4 573.581
R31 IB.n43 IB.t34 573.581
R32 IB.n39 IB.t26 573.581
R33 IB.n37 IB.t24 573.581
R34 IB.n33 IB.t51 573.581
R35 IB.n31 IB.t55 573.581
R36 IB.n27 IB.t56 573.581
R37 IB.n25 IB.t42 573.581
R38 IB.n22 IB.t22 573.581
R39 IB.n20 IB.t14 573.581
R40 IB.n2 IB.n0 175.477
R41 IB.n11 IB.n9 175.476
R42 IB.n11 IB.n10 174.326
R43 IB.n13 IB.n12 174.326
R44 IB.n15 IB.n14 174.326
R45 IB.n17 IB.n16 174.326
R46 IB.n8 IB.n7 174.326
R47 IB.n6 IB.n5 174.326
R48 IB.n4 IB.n3 174.326
R49 IB.n2 IB.n1 174.326
R50 IB.n93 IB.n87 161.685
R51 IB.n29 IB.n23 161.685
R52 IB.n93 IB.n92 161.3
R53 IB.n99 IB.n98 161.3
R54 IB.n105 IB.n104 161.3
R55 IB.n111 IB.n110 161.3
R56 IB.n117 IB.n116 161.3
R57 IB.n123 IB.n122 161.3
R58 IB.n129 IB.n128 161.3
R59 IB.n135 IB.n134 161.3
R60 IB.n136 IB.n82 161.3
R61 IB.n77 IB.n76 161.3
R62 IB.n71 IB.n70 161.3
R63 IB.n65 IB.n64 161.3
R64 IB.n59 IB.n58 161.3
R65 IB.n53 IB.n52 161.3
R66 IB.n47 IB.n46 161.3
R67 IB.n41 IB.n40 161.3
R68 IB.n35 IB.n34 161.3
R69 IB.n29 IB.n28 161.3
R70 IB.n86 IB.n85 33.7405
R71 IB.n84 IB.n83 33.7405
R72 IB.n91 IB.n90 33.7405
R73 IB.n89 IB.n88 33.7405
R74 IB.n97 IB.n96 33.7405
R75 IB.n95 IB.n94 33.7405
R76 IB.n103 IB.n102 33.7405
R77 IB.n101 IB.n100 33.7405
R78 IB.n109 IB.n108 33.7405
R79 IB.n107 IB.n106 33.7405
R80 IB.n115 IB.n114 33.7405
R81 IB.n113 IB.n112 33.7405
R82 IB.n121 IB.n120 33.7405
R83 IB.n119 IB.n118 33.7405
R84 IB.n127 IB.n126 33.7405
R85 IB.n125 IB.n124 33.7405
R86 IB.n133 IB.n132 33.7405
R87 IB.n131 IB.n130 33.7405
R88 IB.n81 IB.n80 33.7405
R89 IB.n79 IB.n78 33.7405
R90 IB.n75 IB.n74 33.7405
R91 IB.n73 IB.n72 33.7405
R92 IB.n69 IB.n68 33.7405
R93 IB.n67 IB.n66 33.7405
R94 IB.n63 IB.n62 33.7405
R95 IB.n61 IB.n60 33.7405
R96 IB.n57 IB.n56 33.7405
R97 IB.n55 IB.n54 33.7405
R98 IB.n51 IB.n50 33.7405
R99 IB.n49 IB.n48 33.7405
R100 IB.n45 IB.n44 33.7405
R101 IB.n43 IB.n42 33.7405
R102 IB.n39 IB.n38 33.7405
R103 IB.n37 IB.n36 33.7405
R104 IB.n33 IB.n32 33.7405
R105 IB.n31 IB.n30 33.7405
R106 IB.n27 IB.n26 33.7405
R107 IB.n25 IB.n24 33.7405
R108 IB.n22 IB.n21 33.7405
R109 IB.n20 IB.n19 33.7405
R110 IB.n87 IB.n84 24.9931
R111 IB.n87 IB.n86 24.9931
R112 IB.n92 IB.n89 24.9931
R113 IB.n92 IB.n91 24.9931
R114 IB.n98 IB.n95 24.9931
R115 IB.n98 IB.n97 24.9931
R116 IB.n104 IB.n101 24.9931
R117 IB.n104 IB.n103 24.9931
R118 IB.n110 IB.n107 24.9931
R119 IB.n110 IB.n109 24.9931
R120 IB.n116 IB.n113 24.9931
R121 IB.n116 IB.n115 24.9931
R122 IB.n122 IB.n119 24.9931
R123 IB.n122 IB.n121 24.9931
R124 IB.n128 IB.n125 24.9931
R125 IB.n128 IB.n127 24.9931
R126 IB.n134 IB.n131 24.9931
R127 IB.n134 IB.n133 24.9931
R128 IB.n82 IB.n79 24.9931
R129 IB.n82 IB.n81 24.9931
R130 IB.n76 IB.n73 24.9931
R131 IB.n76 IB.n75 24.9931
R132 IB.n70 IB.n67 24.9931
R133 IB.n70 IB.n69 24.9931
R134 IB.n64 IB.n61 24.9931
R135 IB.n64 IB.n63 24.9931
R136 IB.n58 IB.n55 24.9931
R137 IB.n58 IB.n57 24.9931
R138 IB.n52 IB.n49 24.9931
R139 IB.n52 IB.n51 24.9931
R140 IB.n46 IB.n43 24.9931
R141 IB.n46 IB.n45 24.9931
R142 IB.n40 IB.n37 24.9931
R143 IB.n40 IB.n39 24.9931
R144 IB.n34 IB.n31 24.9931
R145 IB.n34 IB.n33 24.9931
R146 IB.n28 IB.n25 24.9931
R147 IB.n28 IB.n27 24.9931
R148 IB.n23 IB.n20 24.9931
R149 IB.n23 IB.n22 24.9931
R150 IB.n9 IB.t19 11.4291
R151 IB.n9 IB.t21 11.4291
R152 IB.n10 IB.t39 11.4291
R153 IB.n10 IB.t7 11.4291
R154 IB.n12 IB.t29 11.4291
R155 IB.n12 IB.t37 11.4291
R156 IB.n14 IB.t13 11.4291
R157 IB.n14 IB.t11 11.4291
R158 IB.n16 IB.t33 11.4291
R159 IB.n16 IB.t3 11.4291
R160 IB.n7 IB.t31 11.4291
R161 IB.n7 IB.t1 11.4291
R162 IB.n5 IB.t9 11.4291
R163 IB.n5 IB.t17 11.4291
R164 IB.n3 IB.t35 11.4291
R165 IB.n3 IB.t5 11.4291
R166 IB.n1 IB.t25 11.4291
R167 IB.n1 IB.t27 11.4291
R168 IB.n0 IB.t15 11.4291
R169 IB.n0 IB.t23 11.4291
R170 IB IB.n18 5.438
R171 IB IB.n136 5.438
R172 IB.n6 IB.n4 1.15229
R173 IB.n15 IB.n13 1.15229
R174 IB.n18 IB.n8 0.768357
R175 IB.n35 IB.n29 0.384429
R176 IB.n41 IB.n35 0.384429
R177 IB.n47 IB.n41 0.384429
R178 IB.n53 IB.n47 0.384429
R179 IB.n59 IB.n53 0.384429
R180 IB.n65 IB.n59 0.384429
R181 IB.n71 IB.n65 0.384429
R182 IB.n77 IB.n71 0.384429
R183 IB.n136 IB.n77 0.384429
R184 IB.n136 IB.n135 0.384429
R185 IB.n135 IB.n129 0.384429
R186 IB.n129 IB.n123 0.384429
R187 IB.n123 IB.n117 0.384429
R188 IB.n117 IB.n111 0.384429
R189 IB.n111 IB.n105 0.384429
R190 IB.n105 IB.n99 0.384429
R191 IB.n99 IB.n93 0.384429
R192 IB.n4 IB.n2 0.384429
R193 IB.n8 IB.n6 0.384429
R194 IB.n18 IB.n17 0.384429
R195 IB.n17 IB.n15 0.384429
R196 IB.n13 IB.n11 0.384429
R197 VSS.n43 VSS.n42 5730.23
R198 VSS.n44 VSS.n43 1193.41
R199 VSS.n43 VSS.n0 1193.02
R200 VSS.n50 VSS.n1 1179.68
R201 VSS.n17 VSS.n16 1179.68
R202 VSS.n64 VSS.n61 1179.68
R203 VSS.n33 VSS.n32 1179.68
R204 VSS.n80 VSS.n79 1179.3
R205 VSS.n76 VSS.n58 1179.3
R206 VSS.n73 VSS.n72 1179.3
R207 VSS.n71 VSS.n70 1179.3
R208 VSS.n67 VSS.n61 1179.3
R209 VSS.n18 VSS.n17 1179.3
R210 VSS.n21 VSS.n12 1179.3
R211 VSS.n26 VSS.n25 1179.3
R212 VSS.n28 VSS.n27 1179.3
R213 VSS.n32 VSS.n8 1179.3
R214 VSS.n35 VSS.n34 1179.3
R215 VSS.n37 VSS.n36 1179.3
R216 VSS.n40 VSS.n5 1179.3
R217 VSS.n47 VSS.n46 1179.3
R218 VSS.n50 VSS.n3 1179.3
R219 VSS.n55 VSS.n54 1179.3
R220 VSS.n85 VSS.n56 1179.3
R221 VSS.n82 VSS.n81 1179.3
R222 VSS.n54 VSS.n1 1179.3
R223 VSS.n86 VSS.n85 1179.3
R224 VSS.n34 VSS.n33 1179.3
R225 VSS.n37 VSS.n6 1179.3
R226 VSS.n78 VSS.n77 232.148
R227 VSS.n75 VSS.n74 232.148
R228 VSS.n62 VSS.n60 232.148
R229 VSS.n69 VSS.n68 232.148
R230 VSS.n66 VSS.n65 232.148
R231 VSS.n15 VSS.n13 232.148
R232 VSS.n20 VSS.n19 232.148
R233 VSS.n23 VSS.n22 232.148
R234 VSS.n59 VSS.n57 176.291
R235 VSS.n24 VSS.n11 176.291
R236 VSS.n30 VSS.n29 120.433
R237 VSS.n31 VSS.n9 120.433
R238 VSS.n10 VSS.n7 120.433
R239 VSS.n39 VSS.n38 120.433
R240 VSS.n49 VSS.n48 120.433
R241 VSS.n52 VSS.n51 120.433
R242 VSS.n53 VSS.n2 120.433
R243 VSS.n84 VSS.n83 120.433
R244 VSS.n79 VSS.n59 116.075
R245 VSS.n79 VSS.n78 116.075
R246 VSS.n77 VSS.n76 116.075
R247 VSS.n76 VSS.n75 116.075
R248 VSS.n74 VSS.n73 116.075
R249 VSS.n73 VSS.n60 116.075
R250 VSS.n70 VSS.n62 116.075
R251 VSS.n70 VSS.n69 116.075
R252 VSS.n68 VSS.n67 116.075
R253 VSS.n67 VSS.n66 116.075
R254 VSS.n65 VSS.n64 116.075
R255 VSS.n64 VSS.n63 116.075
R256 VSS.n16 VSS.n14 116.075
R257 VSS.n16 VSS.n15 116.075
R258 VSS.n18 VSS.n13 116.075
R259 VSS.n19 VSS.n18 116.075
R260 VSS.n21 VSS.n20 116.075
R261 VSS.n22 VSS.n21 116.075
R262 VSS.n25 VSS.n23 116.075
R263 VSS.n25 VSS.n24 116.075
R264 VSS.n28 VSS.n11 60.2169
R265 VSS.n29 VSS.n28 60.2169
R266 VSS.n32 VSS.n30 60.2169
R267 VSS.n32 VSS.n31 60.2169
R268 VSS.n34 VSS.n9 60.2169
R269 VSS.n34 VSS.n10 60.2169
R270 VSS.n37 VSS.n7 60.2169
R271 VSS.n38 VSS.n37 60.2169
R272 VSS.n40 VSS.n39 60.2169
R273 VSS.n41 VSS.n40 60.2169
R274 VSS.n42 VSS.n41 60.2169
R275 VSS.n42 VSS.n4 60.2169
R276 VSS.n47 VSS.n4 60.2169
R277 VSS.n48 VSS.n47 60.2169
R278 VSS.n50 VSS.n49 60.2169
R279 VSS.n51 VSS.n50 60.2169
R280 VSS.n54 VSS.n52 60.2169
R281 VSS.n54 VSS.n53 60.2169
R282 VSS.n85 VSS.n2 60.2169
R283 VSS.n85 VSS.n84 60.2169
R284 VSS.n83 VSS.n82 60.2169
R285 VSS.n82 VSS.n57 60.2169
R286 VSS.n44 VSS.n6 8.14852
R287 VSS.n87 VSS.n86 8.098
R288 VSS.n46 VSS 7.5005
R289 VSS VSS.n87 4.01561
R290 VSS VSS.n45 3.973
R291 VSS.n86 VSS.n1 0.384429
R292 VSS.n17 VSS.n12 0.384429
R293 VSS.n26 VSS.n12 0.384429
R294 VSS.n27 VSS.n26 0.384429
R295 VSS.n27 VSS.n8 0.384429
R296 VSS.n35 VSS.n8 0.384429
R297 VSS.n36 VSS.n35 0.384429
R298 VSS.n36 VSS.n5 0.384429
R299 VSS.n46 VSS.n5 0.384429
R300 VSS.n46 VSS.n3 0.384429
R301 VSS.n55 VSS.n3 0.384429
R302 VSS.n56 VSS.n55 0.384429
R303 VSS.n81 VSS.n56 0.384429
R304 VSS.n81 VSS.n80 0.384429
R305 VSS.n80 VSS.n58 0.384429
R306 VSS.n72 VSS.n58 0.384429
R307 VSS.n72 VSS.n71 0.384429
R308 VSS.n71 VSS.n61 0.384429
R309 VSS.n33 VSS.n6 0.384429
R310 VSS.n87 VSS.n0 0.10155
R311 VSS.n45 VSS.n44 0.051025
R312 VSS.n45 VSS.n0 0.051025
R313 VIN.n2 VIN.t3 568.582
R314 VIN.n2 VIN.t2 568.582
R315 VIN.n1 VIN.t0 568.582
R316 VIN.n1 VIN.t5 568.582
R317 VIN.n0 VIN.t4 568.582
R318 VIN.n0 VIN.t1 568.582
R319 VIN VIN.n2 161.685
R320 VIN VIN.n0 161.685
R321 VIN VIN.n1 161.3
R322 VIP.n2 VIP.t1 568.582
R323 VIP.n2 VIP.t4 568.582
R324 VIP.n1 VIP.t5 568.582
R325 VIP.n1 VIP.t0 568.582
R326 VIP.n0 VIP.t2 568.582
R327 VIP.n0 VIP.t3 568.582
R328 VIP VIP.n2 161.685
R329 VIP VIP.n0 161.685
R330 VIP VIP.n1 161.3
R331 VCP.n20 VCP.t2 568.582
R332 VCP.n20 VCP.t13 568.582
R333 VCP.n21 VCP.t9 568.582
R334 VCP.n21 VCP.t6 568.582
R335 VCP.n23 VCP.t1 568.582
R336 VCP.n23 VCP.t12 568.582
R337 VCP.n19 VCP.t11 568.582
R338 VCP.n19 VCP.t8 568.582
R339 VCP.n17 VCP.t5 568.582
R340 VCP.n17 VCP.t0 568.582
R341 VCP.n15 VCP.t10 568.582
R342 VCP.n15 VCP.t7 568.582
R343 VCP.n13 VCP.t4 568.582
R344 VCP.n13 VCP.t3 568.582
R345 VCP.n11 VCP.t17 568.582
R346 VCP.n11 VCP.t18 568.582
R347 VCP.n9 VCP.t21 568.582
R348 VCP.n9 VCP.t24 568.582
R349 VCP.n7 VCP.t14 568.582
R350 VCP.n7 VCP.t19 568.582
R351 VCP.n5 VCP.t22 568.582
R352 VCP.n5 VCP.t25 568.582
R353 VCP.n3 VCP.t26 568.582
R354 VCP.n3 VCP.t15 568.582
R355 VCP.n1 VCP.t20 568.582
R356 VCP.n1 VCP.t23 568.582
R357 VCP.n0 VCP.t27 568.582
R358 VCP.n0 VCP.t16 568.582
R359 VCP.n22 VCP.n20 161.685
R360 VCP.n2 VCP.n0 161.685
R361 VCP.n22 VCP.n21 161.3
R362 VCP.n24 VCP.n23 161.3
R363 VCP VCP.n19 161.3
R364 VCP.n18 VCP.n17 161.3
R365 VCP.n16 VCP.n15 161.3
R366 VCP.n14 VCP.n13 161.3
R367 VCP.n12 VCP.n11 161.3
R368 VCP.n10 VCP.n9 161.3
R369 VCP.n8 VCP.n7 161.3
R370 VCP.n6 VCP.n5 161.3
R371 VCP.n4 VCP.n3 161.3
R372 VCP.n2 VCP.n1 161.3
R373 VCP.n14 VCP.n12 83.6639
R374 VCP.n4 VCP.n2 0.384429
R375 VCP.n6 VCP.n4 0.384429
R376 VCP.n8 VCP.n6 0.384429
R377 VCP.n10 VCP.n8 0.384429
R378 VCP.n12 VCP.n10 0.384429
R379 VCP.n16 VCP.n14 0.384429
R380 VCP.n18 VCP.n16 0.384429
R381 VCP VCP.n18 0.384429
R382 VCP VCP.n24 0.384429
R383 VCP.n24 VCP.n22 0.384429
R384 VCN.n1 VCN.t3 568.582
R385 VCN.n1 VCN.t2 568.582
R386 VCN.n0 VCN.t0 568.582
R387 VCN.n0 VCN.t1 568.582
R388 VCN VCN.n0 162.261
R389 VCN VCN.n1 161.493
C0 VCP VCN 0.545572f
C1 VCP m1_2376_2912# 0.042164f
C2 VIP VCP 6.38e-20
C3 VCP m1_1688_2912# 0.042164f
C4 m1_1860_1316# VCP 1.42e-19
C5 VCP VIN 6.38e-20
C6 m1_3322_2072# VCP 0.045168f
C7 VOUT VCP 0.030952f
C8 VDD VCP 0.727132f
C9 VCN m1_3236_2912# 6.47e-19
C10 m1_3236_2912# m1_2376_2912# 0.071096f
C11 VIP m1_3236_2912# 1.77e-20
C12 m1_1860_1316# m1_3236_2912# 0.008118f
C13 m1_742_2912# VCN 6.47e-19
C14 m1_3236_2912# IB 2.28e-20
C15 m1_3322_2072# m1_3236_2912# 0.372001f
C16 VCN m1_2376_2912# -0.013486f
C17 VIP VCN 0.001905f
C18 m1_742_2912# m1_1688_2912# 0.071096f
C19 VIP m1_2376_2912# 2.74e-19
C20 VDD m1_3236_2912# 0.528014f
C21 m1_742_2912# m1_1860_1316# 0.008118f
C22 VCN m1_1688_2912# -0.013486f
C23 m1_742_2912# VIN 1.77e-20
C24 m1_1688_2912# m1_2376_2912# 0.06583f
C25 m1_1860_1316# VCN 4.04e-19
C26 m1_742_2912# IB 5.18e-20
C27 VCN VIN 0.001905f
C28 m1_3322_2072# m1_742_2912# 0.004236f
C29 m1_1860_1316# m1_2376_2912# 0.033221f
C30 VOUT m1_742_2912# 0.206949f
C31 m1_1860_1316# VIP 0.003229f
C32 VIP VIN 0.032645f
C33 m1_3322_2072# VCN -0.008985f
C34 VOUT VCN -0.009394f
C35 m1_742_2912# VDD 0.469336f
C36 m1_2376_2912# IB 2.28e-20
C37 m1_3322_2072# m1_2376_2912# 0.252037f
C38 m1_1860_1316# m1_1688_2912# 0.035798f
C39 VIP IB 0.007439f
C40 m1_3322_2072# VIP 0.033758f
C41 VOUT m1_2376_2912# 1.52e-19
C42 m1_1688_2912# VIN 2.74e-19
C43 VDD VCN 0.079436f
C44 m1_1860_1316# VIN 0.016834f
C45 VDD m1_2376_2912# 0.207661f
C46 m1_1688_2912# IB 2.28e-20
C47 m1_3322_2072# m1_1688_2912# 0.284269f
C48 VDD VIP 0.106853f
C49 VOUT m1_1688_2912# 0.11061f
C50 m1_1860_1316# IB 0.124014f
C51 m1_3322_2072# m1_1860_1316# 0.4688f
C52 VIN IB 0.007861f
C53 VOUT m1_1860_1316# 0.002503f
C54 m1_3322_2072# VIN 0.073545f
C55 VOUT VIN 9.95e-19
C56 VCP m1_3236_2912# 0.011508f
C57 VDD m1_1688_2912# 0.137097f
C58 m1_3322_2072# IB 0.0348f
C59 m1_1860_1316# VDD 0.352098f
C60 VDD VIN 0.062286f
C61 VOUT m1_3322_2072# 0.470806f
C62 VDD IB 0.638734f
C63 m1_3322_2072# VDD 1.088961f
C64 VOUT VDD 0.358016f
C65 m1_742_2912# VCP 0.012096f
C66 VCN VSS 1.209329f
C67 VOUT VSS 5.391904f
C68 VCP VSS 1.337588f
C69 VCP.t16 VSS 0.038209f
C70 VCP.t27 VSS 0.038209f
C71 VCP.n0 VSS 0.126511f
C72 VCP.t23 VSS 0.038209f
C73 VCP.t20 VSS 0.038209f
C74 VCP.n1 VSS 0.126203f
C75 VCP.n2 VSS 0.282136f
C76 VCP.t15 VSS 0.038209f
C77 VCP.t26 VSS 0.038209f
C78 VCP.n3 VSS 0.126203f
C79 VCP.n4 VSS 0.152843f
C80 VCP.t25 VSS 0.038209f
C81 VCP.t22 VSS 0.038209f
C82 VCP.n5 VSS 0.126203f
C83 VCP.n6 VSS 0.152843f
C84 VCP.t19 VSS 0.038209f
C85 VCP.t14 VSS 0.038209f
C86 VCP.n7 VSS 0.126203f
C87 VCP.n8 VSS 0.152843f
C88 VCP.t24 VSS 0.038209f
C89 VCP.t21 VSS 0.038209f
C90 VCP.n9 VSS 0.126203f
C91 VCP.n10 VSS 0.152843f
C92 VCP.t18 VSS 0.038209f
C93 VCP.t17 VSS 0.038209f
C94 VCP.n11 VSS 0.126203f
C95 VCP.n12 VSS 0.537838f
C96 VCP.t3 VSS 0.038209f
C97 VCP.t4 VSS 0.038209f
C98 VCP.n13 VSS 0.126203f
C99 VCP.n14 VSS 0.537838f
C100 VCP.t7 VSS 0.038209f
C101 VCP.t10 VSS 0.038209f
C102 VCP.n15 VSS 0.126203f
C103 VCP.n16 VSS 0.152843f
C104 VCP.t0 VSS 0.038209f
C105 VCP.t5 VSS 0.038209f
C106 VCP.n17 VSS 0.126203f
C107 VCP.n18 VSS 0.152843f
C108 VCP.t8 VSS 0.038209f
C109 VCP.t11 VSS 0.038209f
C110 VCP.n19 VSS 0.126203f
C111 VCP.t13 VSS 0.038209f
C112 VCP.t2 VSS 0.038209f
C113 VCP.n20 VSS 0.126511f
C114 VCP.t6 VSS 0.038209f
C115 VCP.t9 VSS 0.038209f
C116 VCP.n21 VSS 0.126203f
C117 VCP.n22 VSS 0.282136f
C118 VCP.t12 VSS 0.038209f
C119 VCP.t1 VSS 0.038209f
C120 VCP.n23 VSS 0.126203f
C121 VCP.n24 VSS 0.152843f
C122 IB.t15 VSS 0.007053f
C123 IB.t23 VSS 0.007053f
C124 IB.n0 VSS 0.043211f
C125 IB.t25 VSS 0.007053f
C126 IB.t27 VSS 0.007053f
C127 IB.n1 VSS 0.042819f
C128 IB.n2 VSS 0.124181f
C129 IB.t35 VSS 0.007053f
C130 IB.t5 VSS 0.007053f
C131 IB.n3 VSS 0.042819f
C132 IB.n4 VSS 0.064782f
C133 IB.t9 VSS 0.007053f
C134 IB.t17 VSS 0.007053f
C135 IB.n5 VSS 0.042819f
C136 IB.n6 VSS 0.064782f
C137 IB.t31 VSS 0.007053f
C138 IB.t1 VSS 0.007053f
C139 IB.n7 VSS 0.042819f
C140 IB.n8 VSS 0.056529f
C141 IB.t19 VSS 0.007053f
C142 IB.t21 VSS 0.007053f
C143 IB.n9 VSS 0.043211f
C144 IB.t39 VSS 0.007053f
C145 IB.t7 VSS 0.007053f
C146 IB.n10 VSS 0.042819f
C147 IB.n11 VSS 0.124181f
C148 IB.t29 VSS 0.007053f
C149 IB.t37 VSS 0.007053f
C150 IB.n12 VSS 0.042819f
C151 IB.n13 VSS 0.064782f
C152 IB.t13 VSS 0.007053f
C153 IB.t11 VSS 0.007053f
C154 IB.n14 VSS 0.042819f
C155 IB.n15 VSS 0.064782f
C156 IB.t33 VSS 0.007053f
C157 IB.t3 VSS 0.007053f
C158 IB.n16 VSS 0.042819f
C159 IB.n17 VSS 0.048277f
C160 IB.n18 VSS 0.02876f
C161 IB.t14 VSS 0.008096f
C162 IB.n19 VSS 0.008096f
C163 IB.n20 VSS 0.011011f
C164 IB.t22 VSS 0.008096f
C165 IB.n21 VSS 0.008096f
C166 IB.n22 VSS 0.011011f
C167 IB.n23 VSS 0.003655f
C168 IB.t42 VSS 0.008096f
C169 IB.n24 VSS 0.008096f
C170 IB.n25 VSS 0.011011f
C171 IB.t56 VSS 0.008096f
C172 IB.n26 VSS 0.008096f
C173 IB.n27 VSS 0.011011f
C174 IB.n28 VSS 0.003589f
C175 IB.n29 VSS 0.06057f
C176 IB.t55 VSS 0.008096f
C177 IB.n30 VSS 0.008096f
C178 IB.n31 VSS 0.011011f
C179 IB.t51 VSS 0.008096f
C180 IB.n32 VSS 0.008096f
C181 IB.n33 VSS 0.011011f
C182 IB.n34 VSS 0.003589f
C183 IB.n35 VSS 0.032813f
C184 IB.t24 VSS 0.008096f
C185 IB.n36 VSS 0.008096f
C186 IB.n37 VSS 0.011011f
C187 IB.t26 VSS 0.008096f
C188 IB.n38 VSS 0.008096f
C189 IB.n39 VSS 0.011011f
C190 IB.n40 VSS 0.003589f
C191 IB.n41 VSS 0.032813f
C192 IB.t34 VSS 0.008096f
C193 IB.n42 VSS 0.008096f
C194 IB.n43 VSS 0.011011f
C195 IB.t4 VSS 0.008096f
C196 IB.n44 VSS 0.008096f
C197 IB.n45 VSS 0.011011f
C198 IB.n46 VSS 0.003589f
C199 IB.n47 VSS 0.032813f
C200 IB.t49 VSS 0.008096f
C201 IB.n48 VSS 0.008096f
C202 IB.n49 VSS 0.011011f
C203 IB.t50 VSS 0.008096f
C204 IB.n50 VSS 0.008096f
C205 IB.n51 VSS 0.011011f
C206 IB.n52 VSS 0.003589f
C207 IB.n53 VSS 0.032813f
C208 IB.t45 VSS 0.008096f
C209 IB.n54 VSS 0.008096f
C210 IB.n55 VSS 0.011011f
C211 IB.t41 VSS 0.008096f
C212 IB.n56 VSS 0.008096f
C213 IB.n57 VSS 0.011011f
C214 IB.n58 VSS 0.003589f
C215 IB.n59 VSS 0.032813f
C216 IB.t8 VSS 0.008096f
C217 IB.n60 VSS 0.008096f
C218 IB.n61 VSS 0.011011f
C219 IB.t16 VSS 0.008096f
C220 IB.n62 VSS 0.008096f
C221 IB.n63 VSS 0.011011f
C222 IB.n64 VSS 0.003589f
C223 IB.n65 VSS 0.032813f
C224 IB.t30 VSS 0.008096f
C225 IB.n66 VSS 0.008096f
C226 IB.n67 VSS 0.011011f
C227 IB.t0 VSS 0.008096f
C228 IB.n68 VSS 0.008096f
C229 IB.n69 VSS 0.011011f
C230 IB.n70 VSS 0.003589f
C231 IB.n71 VSS 0.032813f
C232 IB.t59 VSS 0.008096f
C233 IB.n72 VSS 0.008096f
C234 IB.n73 VSS 0.011011f
C235 IB.t58 VSS 0.008096f
C236 IB.n74 VSS 0.008096f
C237 IB.n75 VSS 0.011011f
C238 IB.n76 VSS 0.003589f
C239 IB.n77 VSS 0.032813f
C240 IB.t53 VSS 0.008096f
C241 IB.n78 VSS 0.008096f
C242 IB.n79 VSS 0.011011f
C243 IB.t47 VSS 0.008096f
C244 IB.n80 VSS 0.008096f
C245 IB.n81 VSS 0.011011f
C246 IB.n82 VSS 0.003589f
C247 IB.t18 VSS 0.008096f
C248 IB.n83 VSS 0.008096f
C249 IB.n84 VSS 0.011011f
C250 IB.t20 VSS 0.008096f
C251 IB.n85 VSS 0.008096f
C252 IB.n86 VSS 0.011011f
C253 IB.n87 VSS 0.003655f
C254 IB.t40 VSS 0.008096f
C255 IB.n88 VSS 0.008096f
C256 IB.n89 VSS 0.011011f
C257 IB.t54 VSS 0.008096f
C258 IB.n90 VSS 0.008096f
C259 IB.n91 VSS 0.011011f
C260 IB.n92 VSS 0.003589f
C261 IB.n93 VSS 0.06057f
C262 IB.t48 VSS 0.008096f
C263 IB.n94 VSS 0.008096f
C264 IB.n95 VSS 0.011011f
C265 IB.t44 VSS 0.008096f
C266 IB.n96 VSS 0.008096f
C267 IB.n97 VSS 0.011011f
C268 IB.n98 VSS 0.003589f
C269 IB.n99 VSS 0.032813f
C270 IB.t38 VSS 0.008096f
C271 IB.n100 VSS 0.008096f
C272 IB.n101 VSS 0.011011f
C273 IB.t6 VSS 0.008096f
C274 IB.n102 VSS 0.008096f
C275 IB.n103 VSS 0.011011f
C276 IB.n104 VSS 0.003589f
C277 IB.n105 VSS 0.032813f
C278 IB.t28 VSS 0.008096f
C279 IB.n106 VSS 0.008096f
C280 IB.n107 VSS 0.011011f
C281 IB.t36 VSS 0.008096f
C282 IB.n108 VSS 0.008096f
C283 IB.n109 VSS 0.011011f
C284 IB.n110 VSS 0.003589f
C285 IB.n111 VSS 0.032813f
C286 IB.t57 VSS 0.008096f
C287 IB.n112 VSS 0.008096f
C288 IB.n113 VSS 0.011011f
C289 IB.t52 VSS 0.008096f
C290 IB.n114 VSS 0.008096f
C291 IB.n115 VSS 0.011011f
C292 IB.n116 VSS 0.003589f
C293 IB.n117 VSS 0.032813f
C294 IB.t46 VSS 0.008096f
C295 IB.n118 VSS 0.008096f
C296 IB.n119 VSS 0.011011f
C297 IB.t43 VSS 0.008096f
C298 IB.n120 VSS 0.008096f
C299 IB.n121 VSS 0.011011f
C300 IB.n122 VSS 0.003589f
C301 IB.n123 VSS 0.032813f
C302 IB.t12 VSS 0.008096f
C303 IB.n124 VSS 0.008096f
C304 IB.n125 VSS 0.011011f
C305 IB.t10 VSS 0.008096f
C306 IB.n126 VSS 0.008096f
C307 IB.n127 VSS 0.011011f
C308 IB.n128 VSS 0.003589f
C309 IB.n129 VSS 0.032813f
C310 IB.t32 VSS 0.008096f
C311 IB.n130 VSS 0.008096f
C312 IB.n131 VSS 0.011011f
C313 IB.t2 VSS 0.008096f
C314 IB.n132 VSS 0.008096f
C315 IB.n133 VSS 0.011011f
C316 IB.n134 VSS 0.003589f
C317 IB.n135 VSS 0.032813f
C318 IB.n136 VSS 0.036816f
C319 VDD VSS 38.94241f
C320 m1_3322_2072# VSS 1.223634f
C321 m1_3236_2912# VSS 0.211836f
C322 m1_742_2912# VSS 0.278376f
C323 m1_2376_2912# VSS 0.511694f
C324 VIP VSS 1.343369f
C325 m1_1688_2912# VSS 0.696372f
C326 m1_1860_1316# VSS 10.781565f
C327 VIN VSS 1.399827f
C328 IB VSS 17.952675f
.ends
