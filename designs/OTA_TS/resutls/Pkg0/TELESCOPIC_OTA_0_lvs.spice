* NGSPICE file created from TELESCOPIC_OTA_0.ext - technology: sky130A

.subckt SCM_NMOS_15116351_X10_Y1_1774869217 a_402_420# a_200_252# a_147_420#
X0 a_147_420# a_200_252# a_402_420# a_147_420# sky130_fd_pr__nfet_01v8 ad=0.2058 pd=1.75 as=0.2058 ps=1.75 w=1.47 l=0.15 M=20
X1 a_147_420# a_200_252# a_200_252# a_147_420# sky130_fd_pr__nfet_01v8 ad=0.2058 pd=1.75 as=0.2058 ps=1.75 w=1.47 l=0.15 M=20
.ends

.subckt NMOS_4T_47642139_X3_Y1_1774869213 a_230_420# a_200_252# a_147_420# a_241_1232#
X0 a_147_420# a_200_252# a_230_420# a_241_1232# sky130_fd_pr__nfet_01v8 ad=0.2058 pd=1.75 as=0.2058 ps=1.75 w=1.47 l=0.15 M=6
.ends

.subckt PMOS_4T_843553_X7_Y1_1774869215 a_230_420# a_200_252# a_147_420# w_0_0#
X0 a_230_420# a_200_252# a_147_420# w_0_0# sky130_fd_pr__pfet_01v8 ad=0.2058 pd=1.75 as=0.2058 ps=1.75 w=1.47 l=0.15 M=14
.ends

.subckt NMOS_4T_91499272_X1_Y1_1774869214 a_230_420# a_200_252# a_147_420# a_241_1232#
X0 a_230_420# a_200_252# a_147_420# a_241_1232# sky130_fd_pr__nfet_01v8 ad=0.2058 pd=1.75 as=0.38955 ps=3.47 w=1.47 l=0.15 M=2
.ends

.subckt PMOS_S_44280068_X2_Y1_1774869216 a_230_420# a_200_252# w_0_0#
X0 a_230_420# a_200_252# w_0_0# w_0_0# sky130_fd_pr__pfet_01v8 ad=0.2058 pd=1.75 as=0.38955 ps=3.47 w=1.47 l=0.15 M=4
.ends

.subckt TELESCOPIC_OTA_0 IB VCN VOUT VIP VIN VCP VSS VDD
XSCM_NMOS_15116351_X10_Y1_1774869217_0 m1_1860_1316# IB VSS SCM_NMOS_15116351_X10_Y1_1774869217
XNMOS_4T_47642139_X3_Y1_1774869213_0 m1_1688_2912# VIN m1_1860_1316# VSS NMOS_4T_47642139_X3_Y1_1774869213
XNMOS_4T_47642139_X3_Y1_1774869213_1 m1_2376_2912# VIP m1_1860_1316# VSS NMOS_4T_47642139_X3_Y1_1774869213
XPMOS_4T_843553_X7_Y1_1774869215_0 VOUT VCP m1_742_2912# VDD PMOS_4T_843553_X7_Y1_1774869215
XPMOS_4T_843553_X7_Y1_1774869215_1 m1_3322_2072# VCP m1_3236_2912# VDD PMOS_4T_843553_X7_Y1_1774869215
XNMOS_4T_91499272_X1_Y1_1774869214_1 m1_3322_2072# VCN m1_2376_2912# VSS NMOS_4T_91499272_X1_Y1_1774869214
XNMOS_4T_91499272_X1_Y1_1774869214_0 VOUT VCN m1_1688_2912# VSS NMOS_4T_91499272_X1_Y1_1774869214
XPMOS_S_44280068_X2_Y1_1774869216_0 m1_742_2912# m1_3322_2072# VDD PMOS_S_44280068_X2_Y1_1774869216
XPMOS_S_44280068_X2_Y1_1774869216_1 m1_3236_2912# m1_3322_2072# VDD PMOS_S_44280068_X2_Y1_1774869216
.ends
