* NGSPICE file created from TELESCOPIC_OTA_0.ext - technology: sky130A

.subckt PMOS_S_43132956_X9_Y1_1774869329 a_200_252# a_230_378# w_0_0# VSUBS
X0 a_230_378# a_200_252# w_0_0# w_0_0# sky130_fd_pr__pfet_01v8 ad=0.2646 pd=2.17 as=0.2646 ps=2.17 w=1.89 l=0.15
X1 a_230_378# a_200_252# w_0_0# w_0_0# sky130_fd_pr__pfet_01v8 ad=0.2646 pd=2.17 as=0.2646 ps=2.17 w=1.89 l=0.15
X2 w_0_0# a_200_252# a_230_378# w_0_0# sky130_fd_pr__pfet_01v8 ad=0.2646 pd=2.17 as=0.2646 ps=2.17 w=1.89 l=0.15
X3 a_230_378# a_200_252# w_0_0# w_0_0# sky130_fd_pr__pfet_01v8 ad=0.2646 pd=2.17 as=0.2646 ps=2.17 w=1.89 l=0.15
X4 w_0_0# a_200_252# a_230_378# w_0_0# sky130_fd_pr__pfet_01v8 ad=0.2646 pd=2.17 as=0.2646 ps=2.17 w=1.89 l=0.15
X5 w_0_0# a_200_252# a_230_378# w_0_0# sky130_fd_pr__pfet_01v8 ad=0.2646 pd=2.17 as=0.2646 ps=2.17 w=1.89 l=0.15
X6 a_230_378# a_200_252# w_0_0# w_0_0# sky130_fd_pr__pfet_01v8 ad=0.2646 pd=2.17 as=0.2646 ps=2.17 w=1.89 l=0.15
X7 a_230_378# a_200_252# w_0_0# w_0_0# sky130_fd_pr__pfet_01v8 ad=0.2646 pd=2.17 as=0.2646 ps=2.17 w=1.89 l=0.15
X8 w_0_0# a_200_252# a_230_378# w_0_0# sky130_fd_pr__pfet_01v8 ad=0.50085 pd=4.31 as=0.2646 ps=2.17 w=1.89 l=0.15
X9 a_230_378# a_200_252# w_0_0# w_0_0# sky130_fd_pr__pfet_01v8 ad=0.2646 pd=2.17 as=0.2646 ps=2.17 w=1.89 l=0.15
X10 w_0_0# a_200_252# a_230_378# w_0_0# sky130_fd_pr__pfet_01v8 ad=0.2646 pd=2.17 as=0.2646 ps=2.17 w=1.89 l=0.15
X11 w_0_0# a_200_252# a_230_378# w_0_0# sky130_fd_pr__pfet_01v8 ad=0.2646 pd=2.17 as=0.2646 ps=2.17 w=1.89 l=0.15
X12 a_230_378# a_200_252# w_0_0# w_0_0# sky130_fd_pr__pfet_01v8 ad=0.2646 pd=2.17 as=0.50085 ps=4.31 w=1.89 l=0.15
X13 w_0_0# a_200_252# a_230_378# w_0_0# sky130_fd_pr__pfet_01v8 ad=0.2646 pd=2.17 as=0.2646 ps=2.17 w=1.89 l=0.15
X14 w_0_0# a_200_252# a_230_378# w_0_0# sky130_fd_pr__pfet_01v8 ad=0.2646 pd=2.17 as=0.2646 ps=2.17 w=1.89 l=0.15
X15 a_230_378# a_200_252# w_0_0# w_0_0# sky130_fd_pr__pfet_01v8 ad=0.2646 pd=2.17 as=0.2646 ps=2.17 w=1.89 l=0.15
X16 a_230_378# a_200_252# w_0_0# w_0_0# sky130_fd_pr__pfet_01v8 ad=0.2646 pd=2.17 as=0.2646 ps=2.17 w=1.89 l=0.15
X17 w_0_0# a_200_252# a_230_378# w_0_0# sky130_fd_pr__pfet_01v8 ad=0.2646 pd=2.17 as=0.2646 ps=2.17 w=1.89 l=0.15
C0 w_0_0# a_200_252# 3.65491f
C1 w_0_0# a_230_378# 6.65404f
C2 a_230_378# a_200_252# 0.731095f
C3 a_230_378# VSUBS 0.368368f
C4 a_200_252# VSUBS 0.482171f
C5 w_0_0# VSUBS 8.827331f
.ends

.subckt NMOS_4T_91638993_X3_Y2_1774869327 a_200_252# a_230_378# a_147_378# a_241_2408#
X0 a_230_378# a_200_252# a_147_378# a_241_2408# sky130_fd_pr__nfet_01v8 ad=0.2646 pd=2.17 as=0.2646 ps=2.17 w=1.89 l=0.15
X1 a_147_378# a_200_252# a_230_378# a_241_2408# sky130_fd_pr__nfet_01v8 ad=0.2646 pd=2.17 as=0.2646 ps=2.17 w=1.89 l=0.15
X2 a_230_378# a_200_252# a_147_378# a_241_2408# sky130_fd_pr__nfet_01v8 ad=0.2646 pd=2.17 as=0.50085 ps=4.31 w=1.89 l=0.15
X3 a_230_378# a_200_252# a_147_378# a_241_2408# sky130_fd_pr__nfet_01v8 ad=0.2646 pd=2.17 as=0.2646 ps=2.17 w=1.89 l=0.15
X4 a_147_378# a_200_252# a_230_378# a_241_2408# sky130_fd_pr__nfet_01v8 ad=0.2646 pd=2.17 as=0.2646 ps=2.17 w=1.89 l=0.15
X5 a_147_378# a_200_252# a_230_378# a_241_2408# sky130_fd_pr__nfet_01v8 ad=0.2646 pd=2.17 as=0.2646 ps=2.17 w=1.89 l=0.15
X6 a_230_378# a_200_252# a_147_378# a_241_2408# sky130_fd_pr__nfet_01v8 ad=0.2646 pd=2.17 as=0.2646 ps=2.17 w=1.89 l=0.15
X7 a_147_378# a_200_252# a_230_378# a_241_2408# sky130_fd_pr__nfet_01v8 ad=0.50085 pd=4.31 as=0.2646 ps=2.17 w=1.89 l=0.15
X8 a_230_378# a_200_252# a_147_378# a_241_2408# sky130_fd_pr__nfet_01v8 ad=0.2646 pd=2.17 as=0.2646 ps=2.17 w=1.89 l=0.15
X9 a_230_378# a_200_252# a_147_378# a_241_2408# sky130_fd_pr__nfet_01v8 ad=0.2646 pd=2.17 as=0.50085 ps=4.31 w=1.89 l=0.15
X10 a_147_378# a_200_252# a_230_378# a_241_2408# sky130_fd_pr__nfet_01v8 ad=0.2646 pd=2.17 as=0.2646 ps=2.17 w=1.89 l=0.15
X11 a_147_378# a_200_252# a_230_378# a_241_2408# sky130_fd_pr__nfet_01v8 ad=0.50085 pd=4.31 as=0.2646 ps=2.17 w=1.89 l=0.15
C0 a_200_252# a_147_378# 0.929877f
C1 a_200_252# a_230_378# 0.969852f
C2 a_230_378# a_147_378# 4.52522f
C3 a_230_378# a_241_2408# 0.592942f
C4 a_147_378# a_241_2408# 1.22337f
C5 a_200_252# a_241_2408# 2.56395f
.ends

.subckt PMOS_4T_19330511_X7_Y1_1774869328 a_200_252# a_230_378# w_0_0# a_147_378#
+ VSUBS
X0 a_230_378# a_200_252# a_147_378# w_0_0# sky130_fd_pr__pfet_01v8 ad=0.2646 pd=2.17 as=0.2646 ps=2.17 w=1.89 l=0.15
X1 a_230_378# a_200_252# a_147_378# w_0_0# sky130_fd_pr__pfet_01v8 ad=0.2646 pd=2.17 as=0.2646 ps=2.17 w=1.89 l=0.15
X2 a_147_378# a_200_252# a_230_378# w_0_0# sky130_fd_pr__pfet_01v8 ad=0.2646 pd=2.17 as=0.2646 ps=2.17 w=1.89 l=0.15
X3 a_147_378# a_200_252# a_230_378# w_0_0# sky130_fd_pr__pfet_01v8 ad=0.2646 pd=2.17 as=0.2646 ps=2.17 w=1.89 l=0.15
X4 a_147_378# a_200_252# a_230_378# w_0_0# sky130_fd_pr__pfet_01v8 ad=0.2646 pd=2.17 as=0.2646 ps=2.17 w=1.89 l=0.15
X5 a_230_378# a_200_252# a_147_378# w_0_0# sky130_fd_pr__pfet_01v8 ad=0.2646 pd=2.17 as=0.2646 ps=2.17 w=1.89 l=0.15
X6 a_230_378# a_200_252# a_147_378# w_0_0# sky130_fd_pr__pfet_01v8 ad=0.2646 pd=2.17 as=0.2646 ps=2.17 w=1.89 l=0.15
X7 a_230_378# a_200_252# a_147_378# w_0_0# sky130_fd_pr__pfet_01v8 ad=0.2646 pd=2.17 as=0.2646 ps=2.17 w=1.89 l=0.15
X8 a_147_378# a_200_252# a_230_378# w_0_0# sky130_fd_pr__pfet_01v8 ad=0.2646 pd=2.17 as=0.2646 ps=2.17 w=1.89 l=0.15
X9 a_147_378# a_200_252# a_230_378# w_0_0# sky130_fd_pr__pfet_01v8 ad=0.50085 pd=4.31 as=0.2646 ps=2.17 w=1.89 l=0.15
X10 a_230_378# a_200_252# a_147_378# w_0_0# sky130_fd_pr__pfet_01v8 ad=0.2646 pd=2.17 as=0.50085 ps=4.31 w=1.89 l=0.15
X11 a_147_378# a_200_252# a_230_378# w_0_0# sky130_fd_pr__pfet_01v8 ad=0.2646 pd=2.17 as=0.2646 ps=2.17 w=1.89 l=0.15
X12 a_147_378# a_200_252# a_230_378# w_0_0# sky130_fd_pr__pfet_01v8 ad=0.2646 pd=2.17 as=0.2646 ps=2.17 w=1.89 l=0.15
X13 a_230_378# a_200_252# a_147_378# w_0_0# sky130_fd_pr__pfet_01v8 ad=0.2646 pd=2.17 as=0.2646 ps=2.17 w=1.89 l=0.15
C0 w_0_0# a_230_378# 0.219615f
C1 a_230_378# a_200_252# 0.568539f
C2 a_147_378# a_230_378# 4.88163f
C3 w_0_0# a_200_252# 2.16226f
C4 w_0_0# a_147_378# 0.399036f
C5 a_147_378# a_200_252# 0.568868f
C6 a_230_378# VSUBS 0.285614f
C7 a_147_378# VSUBS 0.307382f
C8 a_200_252# VSUBS 0.399436f
C9 w_0_0# VSUBS 7.2786f
.ends

.subckt SCM_NMOS_27386274_X2_Y1_1774869330 a_200_252# a_402_378# a_147_378#
X0 a_402_378# a_200_252# a_147_378# a_147_378# sky130_fd_pr__nfet_01v8 ad=0.2646 pd=2.17 as=0.2646 ps=2.17 w=1.89 l=0.15
X1 a_200_252# a_200_252# a_147_378# a_147_378# sky130_fd_pr__nfet_01v8 ad=0.2646 pd=2.17 as=0.2646 ps=2.17 w=1.89 l=0.15
X2 a_147_378# a_200_252# a_402_378# a_147_378# sky130_fd_pr__nfet_01v8 ad=0.2646 pd=2.17 as=0.2646 ps=2.17 w=1.89 l=0.15
X3 a_147_378# a_200_252# a_200_252# a_147_378# sky130_fd_pr__nfet_01v8 ad=0.50085 pd=4.31 as=0.2646 ps=2.17 w=1.89 l=0.15
X4 a_402_378# a_200_252# a_147_378# a_147_378# sky130_fd_pr__nfet_01v8 ad=0.2646 pd=2.17 as=0.2646 ps=2.17 w=1.89 l=0.15
X5 a_200_252# a_200_252# a_147_378# a_147_378# sky130_fd_pr__nfet_01v8 ad=0.2646 pd=2.17 as=0.50085 ps=4.31 w=1.89 l=0.15
X6 a_147_378# a_200_252# a_200_252# a_147_378# sky130_fd_pr__nfet_01v8 ad=0.2646 pd=2.17 as=0.2646 ps=2.17 w=1.89 l=0.15
X7 a_147_378# a_200_252# a_402_378# a_147_378# sky130_fd_pr__nfet_01v8 ad=0.2646 pd=2.17 as=0.2646 ps=2.17 w=1.89 l=0.15
C0 a_200_252# a_402_378# 0.390051f
C1 a_402_378# a_147_378# 1.48074f
C2 a_200_252# a_147_378# 4.04848f
.ends

.subckt NMOS_4T_36089430_X1_Y1_1774869326 a_200_252# a_230_378# a_147_378# a_241_1232#
X0 a_230_378# a_200_252# a_147_378# a_241_1232# sky130_fd_pr__nfet_01v8 ad=0.2646 pd=2.17 as=0.50085 ps=4.31 w=1.89 l=0.15
X1 a_147_378# a_200_252# a_230_378# a_241_1232# sky130_fd_pr__nfet_01v8 ad=0.50085 pd=4.31 as=0.2646 ps=2.17 w=1.89 l=0.15
C0 a_200_252# a_147_378# 0.081755f
C1 a_200_252# a_230_378# 0.085611f
C2 a_230_378# a_147_378# 0.702653f
C3 a_230_378# a_241_1232# 0.122961f
C4 a_147_378# a_241_1232# 0.41283f
C5 a_200_252# a_241_1232# 0.573641f
.ends

.subckt TELESCOPIC_OTA_0 IB VCN VOUT VIP VIN VCP VSS VDD
XPMOS_S_43132956_X9_Y1_1774869329_0 m1_4010_1652# m1_914_1568# VDD VSS PMOS_S_43132956_X9_Y1_1774869329
XNMOS_4T_91638993_X3_Y2_1774869327_0 VCN VOUT m1_2150_1400# VSS NMOS_4T_91638993_X3_Y2_1774869327
XPMOS_S_43132956_X9_Y1_1774869329_1 m1_4010_1652# m1_4526_1568# VDD VSS PMOS_S_43132956_X9_Y1_1774869329
XNMOS_4T_91638993_X3_Y2_1774869327_1 VCN m1_4010_1652# m1_3236_1400# VSS NMOS_4T_91638993_X3_Y2_1774869327
XPMOS_4T_19330511_X7_Y1_1774869328_0 VCP VOUT VDD m1_914_1568# VSS PMOS_4T_19330511_X7_Y1_1774869328
XPMOS_4T_19330511_X7_Y1_1774869328_1 VCP m1_4010_1652# VDD m1_4526_1568# VSS PMOS_4T_19330511_X7_Y1_1774869328
XSCM_NMOS_27386274_X2_Y1_1774869330_0 IB m1_2838_1316# VSS SCM_NMOS_27386274_X2_Y1_1774869330
XNMOS_4T_36089430_X1_Y1_1774869326_0 VIN m1_2150_1400# m1_2838_1316# VSS NMOS_4T_36089430_X1_Y1_1774869326
XNMOS_4T_36089430_X1_Y1_1774869326_1 VIP m1_3236_1400# m1_2838_1316# VSS NMOS_4T_36089430_X1_Y1_1774869326
R0 VDD.n42 VDD 1761.27
R1 VDD.n15 VDD.n14 379.685
R2 VDD.n39 VDD.n38 379.685
R3 VDD.n18 VDD.n17 379.685
R4 VDD.n17 VDD.n15 379.3
R5 VDD.n19 VDD.n9 379.3
R6 VDD.n24 VDD.n23 379.3
R7 VDD.n27 VDD.n26 379.3
R8 VDD.n30 VDD.n4 379.3
R9 VDD.n35 VDD.n34 379.3
R10 VDD.n40 VDD.n39 379.3
R11 VDD.n19 VDD.n18 379.3
R12 VDD.n23 VDD.n6 379.3
R13 VDD.n28 VDD.n27 379.3
R14 VDD.n30 VDD.n29 379.3
R15 VDD.n34 VDD.n1 379.3
R16 VDD.n41 VDD.n40 379.3
R17 VDD.n13 VDD.n11 27.0177
R18 VDD.n16 VDD.n10 27.0177
R19 VDD.n21 VDD.n20 27.0177
R20 VDD.n22 VDD.n7 27.0177
R21 VDD.n8 VDD.n5 27.0177
R22 VDD.n32 VDD.n31 27.0177
R23 VDD.n33 VDD.n2 27.0177
R24 VDD.n36 VDD.n3 27.0177
R25 VDD.n14 VDD.n12 13.5091
R26 VDD.n14 VDD.n13 13.5091
R27 VDD.n17 VDD.n11 13.5091
R28 VDD.n17 VDD.n16 13.5091
R29 VDD.n19 VDD.n10 13.5091
R30 VDD.n20 VDD.n19 13.5091
R31 VDD.n23 VDD.n21 13.5091
R32 VDD.n23 VDD.n22 13.5091
R33 VDD.n27 VDD.n7 13.5091
R34 VDD.n27 VDD.n8 13.5091
R35 VDD.n30 VDD.n5 13.5091
R36 VDD.n31 VDD.n30 13.5091
R37 VDD.n34 VDD.n32 13.5091
R38 VDD.n34 VDD.n33 13.5091
R39 VDD.n40 VDD.n2 13.5091
R40 VDD.n40 VDD.n3 13.5091
R41 VDD.n38 VDD.n36 13.5091
R42 VDD.n38 VDD.n37 13.5091
R43 VDD.n42 VDD.n41 9.41729
R44 VDD.n25 VDD.n0 9.29097
R45 VDD VDD.n0 4.54783
R46 VDD VDD.n42 3.93746
R47 VDD VDD.n0 3.58615
R48 VDD.n15 VDD.n9 0.384429
R49 VDD.n24 VDD.n9 0.384429
R50 VDD.n26 VDD.n24 0.384429
R51 VDD.n35 VDD.n4 0.384429
R52 VDD.n39 VDD.n35 0.384429
R53 VDD.n18 VDD.n6 0.384429
R54 VDD.n28 VDD.n6 0.384429
R55 VDD.n29 VDD.n28 0.384429
R56 VDD.n29 VDD.n1 0.384429
R57 VDD.n41 VDD.n1 0.384429
R58 VDD.n26 VDD.n25 0.192464
R59 VDD.n25 VDD.n4 0.192464
R60 VCN.n2 VCN.t7 568.582
R61 VCN.n2 VCN.t3 568.582
R62 VCN.n1 VCN.t1 568.582
R63 VCN.n1 VCN.t6 568.582
R64 VCN.n0 VCN.t4 568.582
R65 VCN.n0 VCN.t2 568.582
R66 VCN.n15 VCN.t11 568.582
R67 VCN.n15 VCN.t8 568.582
R68 VCN.n14 VCN.t5 568.582
R69 VCN.n14 VCN.t0 568.582
R70 VCN.n13 VCN.t10 568.582
R71 VCN.n13 VCN.t9 568.582
R72 VCN.n6 VCN.t14 568.582
R73 VCN.n6 VCN.t16 568.582
R74 VCN.n5 VCN.t18 568.582
R75 VCN.n5 VCN.t13 568.582
R76 VCN.n4 VCN.t15 568.582
R77 VCN.n4 VCN.t19 568.582
R78 VCN.n10 VCN.t21 568.582
R79 VCN.n10 VCN.t22 568.582
R80 VCN.n9 VCN.t12 568.582
R81 VCN.n9 VCN.t17 568.582
R82 VCN.n8 VCN.t20 568.582
R83 VCN.n8 VCN.t23 568.582
R84 VCN.n3 VCN.n2 161.685
R85 VCN.n3 VCN.n0 161.685
R86 VCN.n16 VCN.n15 161.685
R87 VCN.n16 VCN.n13 161.685
R88 VCN.n7 VCN.n6 161.685
R89 VCN.n7 VCN.n4 161.685
R90 VCN.n11 VCN.n10 161.685
R91 VCN.n11 VCN.n8 161.685
R92 VCN.n3 VCN.n1 161.3
R93 VCN.n16 VCN.n14 161.3
R94 VCN.n7 VCN.n5 161.3
R95 VCN.n11 VCN.n9 161.3
R96 VCN VCN.n12 10.9201
R97 VCN.n12 VCN.n7 5.813
R98 VCN.n12 VCN.n11 5.813
R99 VCN VCN.n3 5.813
R100 VCN VCN.n16 5.813
R101 VSS.n10 VSS.n1 139579
R102 VSS.n6 VSS.n1 109659
R103 VSS.n8 VSS.n1 5011.4
R104 VSS.n10 VSS.n9 1378.18
R105 VSS.n7 VSS.n6 1378.18
R106 VSS.n11 VSS.n10 1191.16
R107 VSS.n6 VSS.n5 1190.82
R108 VSS.n4 VSS.n1 790.466
R109 VSS.n7 VSS.n2 504.24
R110 VSS.n9 VSS.n2 503.856
R111 VSS.n5 VSS.n4 406.286
R112 VSS.n4 VSS.n0 406.286
R113 VSS.n9 VSS.n8 372.815
R114 VSS.n8 VSS.n7 372.815
R115 VSS VSS.n2 7.5005
R116 VSS VSS.n11 3.99212
R117 VSS.n3 VSS 3.973
R118 VSS.n5 VSS.n3 0.2026
R119 VSS.n11 VSS.n0 0.10155
R120 VSS.n3 VSS.n0 0.051025
R121 VCP.n20 VCP.t11 568.582
R122 VCP.n20 VCP.t10 568.582
R123 VCP.n21 VCP.t3 568.582
R124 VCP.n21 VCP.t0 568.582
R125 VCP.n23 VCP.t12 568.582
R126 VCP.n23 VCP.t7 568.582
R127 VCP.n19 VCP.t4 568.582
R128 VCP.n19 VCP.t1 568.582
R129 VCP.n17 VCP.t8 568.582
R130 VCP.n17 VCP.t5 568.582
R131 VCP.n15 VCP.t2 568.582
R132 VCP.n15 VCP.t13 568.582
R133 VCP.n13 VCP.t9 568.582
R134 VCP.n13 VCP.t6 568.582
R135 VCP.n11 VCP.t20 568.582
R136 VCP.n11 VCP.t23 568.582
R137 VCP.n9 VCP.t27 568.582
R138 VCP.n9 VCP.t16 568.582
R139 VCP.n7 VCP.t19 568.582
R140 VCP.n7 VCP.t22 568.582
R141 VCP.n5 VCP.t15 568.582
R142 VCP.n5 VCP.t18 568.582
R143 VCP.n3 VCP.t21 568.582
R144 VCP.n3 VCP.t26 568.582
R145 VCP.n1 VCP.t14 568.582
R146 VCP.n1 VCP.t17 568.582
R147 VCP.n0 VCP.t24 568.582
R148 VCP.n0 VCP.t25 568.582
R149 VCP.n22 VCP.n20 161.685
R150 VCP.n2 VCP.n0 161.685
R151 VCP.n22 VCP.n21 161.3
R152 VCP.n24 VCP.n23 161.3
R153 VCP VCP.n19 161.3
R154 VCP.n18 VCP.n17 161.3
R155 VCP.n16 VCP.n15 161.3
R156 VCP.n14 VCP.n13 161.3
R157 VCP.n12 VCP.n11 161.3
R158 VCP.n10 VCP.n9 161.3
R159 VCP.n8 VCP.n7 161.3
R160 VCP.n6 VCP.n5 161.3
R161 VCP.n4 VCP.n3 161.3
R162 VCP.n2 VCP.n1 161.3
R163 VCP.n14 VCP.n12 5.75943
R164 VCP.n4 VCP.n2 0.384429
R165 VCP.n6 VCP.n4 0.384429
R166 VCP.n8 VCP.n6 0.384429
R167 VCP.n10 VCP.n8 0.384429
R168 VCP.n12 VCP.n10 0.384429
R169 VCP.n16 VCP.n14 0.384429
R170 VCP.n18 VCP.n16 0.384429
R171 VCP VCP.n18 0.384429
R172 VCP VCP.n24 0.384429
R173 VCP.n24 VCP.n22 0.384429
R174 IB.n7 IB.t0 568.582
R175 IB.n7 IB.t2 568.582
R176 IB.n6 IB.t9 568.582
R177 IB.n6 IB.t8 568.582
R178 IB.n4 IB.t11 568.582
R179 IB.n4 IB.t10 568.582
R180 IB.n3 IB.t4 568.582
R181 IB.n3 IB.t6 568.582
R182 IB.n8 IB.n7 161.685
R183 IB.n5 IB.n3 161.685
R184 IB.n8 IB.n6 161.3
R185 IB.n5 IB.n4 161.3
R186 IB.n2 IB.n0 153.401
R187 IB.n2 IB.n1 153.018
R188 IB.n1 IB.t1 8.88939
R189 IB.n1 IB.t3 8.88939
R190 IB.n0 IB.t5 8.88939
R191 IB.n0 IB.t7 8.88939
R192 IB IB.n2 5.438
R193 IB IB.n8 5.438
R194 IB.n8 IB.n5 0.384429
R195 VIN.n0 VIN.t0 568.582
R196 VIN.n0 VIN.t1 568.582
R197 VIN VIN.n0 161.493
R198 VIP.n0 VIP.t1 568.582
R199 VIP.n0 VIP.t0 568.582
R200 VIP VIP.n0 161.493
C0 m1_3236_1400# m1_4010_1652# 0.263371f
C1 m1_914_1568# VIN 8.33e-19
C2 m1_914_1568# IB 5.06e-20
C3 m1_4526_1568# VCN 0.003305f
C4 VIP m1_4010_1652# 6.35e-19
C5 VCP VCN 2.8e-19
C6 VDD VCN 0.729169f
C7 VOUT m1_2838_1316# 0.053657f
C8 VIN m1_4010_1652# 1.91e-20
C9 IB m1_4010_1652# 0.036569f
C10 m1_2150_1400# m1_4526_1568# 6.83e-20
C11 VCP m1_2150_1400# 0.035735f
C12 m1_2150_1400# VDD 0.284351f
C13 VCP m1_914_1568# 0.014512f
C14 VDD m1_914_1568# 0.225592f
C15 VOUT VCN 0.039154f
C16 VIP m1_3236_1400# -0.007703f
C17 VOUT m1_2150_1400# 0.42273f
C18 m1_4526_1568# m1_4010_1652# 0.584065f
C19 VCP m1_4010_1652# 0.027446f
C20 VDD m1_4010_1652# 0.649395f
C21 m1_2838_1316# VCN 0.001299f
C22 m1_3236_1400# IB 0.029922f
C23 VOUT m1_914_1568# 0.547692f
C24 m1_2838_1316# m1_2150_1400# 0.111782f
C25 VIP IB 0.033201f
C26 m1_2838_1316# m1_914_1568# 0.037104f
C27 VOUT m1_4010_1652# 0.312172f
C28 VIN IB 0.03547f
C29 m1_2150_1400# VCN 0.069311f
C30 m1_4526_1568# m1_3236_1400# 0.012161f
C31 VCP m1_3236_1400# 0.035735f
C32 VDD m1_3236_1400# 0.26476f
C33 m1_2838_1316# m1_4010_1652# 0.03936f
C34 m1_914_1568# VCN 0.003393f
C35 VIP m1_4526_1568# 8.33e-19
C36 VIP VDD 0.056441f
C37 VIP VCP 0.064961f
C38 m1_2150_1400# m1_914_1568# 0.008405f
C39 m1_4526_1568# IB 4.98e-20
C40 VCP VIN 0.064961f
C41 VDD VIN 0.061467f
C42 VCP IB 0.318902f
C43 VDD IB 0.114349f
C44 VOUT m1_3236_1400# 0.004444f
C45 VCN m1_4010_1652# 0.26107f
C46 m1_2150_1400# m1_4010_1652# 0.10915f
C47 m1_2838_1316# m1_3236_1400# 0.111696f
C48 m1_914_1568# m1_4010_1652# 0.001944f
C49 VOUT VIN 7.86e-19
C50 VOUT IB 0.026817f
C51 VCP m1_4526_1568# 0.018289f
C52 m1_4526_1568# VDD 0.203063f
C53 VCP VDD 0.297976f
C54 VIP m1_2838_1316# -0.013608f
C55 m1_3236_1400# VCN 0.124421f
C56 m1_2838_1316# VIN -0.013608f
C57 m1_2838_1316# IB 0.237707f
C58 m1_2150_1400# m1_3236_1400# 0.12715f
C59 VIP VCN 1.67e-20
C60 VOUT m1_4526_1568# 7.45e-20
C61 VCP VOUT 0.014968f
C62 VOUT VDD 0.262471f
C63 m1_3236_1400# m1_914_1568# 6.83e-20
C64 VIN VCN 1.67e-20
C65 IB VCN 0.004494f
C66 m1_2838_1316# m1_4526_1568# 0.037104f
C67 VCP m1_2838_1316# 0.344895f
C68 m1_2838_1316# VDD 0.127607f
C69 m1_2150_1400# VIN -0.007703f
C70 m1_2150_1400# IB 0.03732f
C71 VCP VSS 1.945891f
C72 VOUT VSS 11.474931f
C73 VCP.t24 VSS 0.040838f
C74 VCP.t25 VSS 0.040838f
C75 VCP.n0 VSS 0.088584f
C76 VCP.t14 VSS 0.040838f
C77 VCP.t17 VSS 0.040838f
C78 VCP.n1 VSS 0.088368f
C79 VCP.n2 VSS 0.197554f
C80 VCP.t21 VSS 0.040838f
C81 VCP.t26 VSS 0.040838f
C82 VCP.n3 VSS 0.088368f
C83 VCP.n4 VSS 0.107022f
C84 VCP.t15 VSS 0.040838f
C85 VCP.t18 VSS 0.040838f
C86 VCP.n5 VSS 0.088368f
C87 VCP.n6 VSS 0.107022f
C88 VCP.t19 VSS 0.040838f
C89 VCP.t22 VSS 0.040838f
C90 VCP.n7 VSS 0.088368f
C91 VCP.n8 VSS 0.107022f
C92 VCP.t27 VSS 0.040838f
C93 VCP.t16 VSS 0.040838f
C94 VCP.n9 VSS 0.088368f
C95 VCP.n10 VSS 0.107022f
C96 VCP.t20 VSS 0.040838f
C97 VCP.t23 VSS 0.040838f
C98 VCP.n11 VSS 0.088368f
C99 VCP.n12 VSS 0.483835f
C100 VCP.t9 VSS 0.040838f
C101 VCP.t6 VSS 0.040838f
C102 VCP.n13 VSS 0.088368f
C103 VCP.n14 VSS 0.483835f
C104 VCP.t2 VSS 0.040838f
C105 VCP.t13 VSS 0.040838f
C106 VCP.n15 VSS 0.088368f
C107 VCP.n16 VSS 0.107022f
C108 VCP.t8 VSS 0.040838f
C109 VCP.t5 VSS 0.040838f
C110 VCP.n17 VSS 0.088368f
C111 VCP.n18 VSS 0.107022f
C112 VCP.t4 VSS 0.040838f
C113 VCP.t1 VSS 0.040838f
C114 VCP.n19 VSS 0.088368f
C115 VCP.t11 VSS 0.040838f
C116 VCP.t10 VSS 0.040838f
C117 VCP.n20 VSS 0.088584f
C118 VCP.t3 VSS 0.040838f
C119 VCP.t0 VSS 0.040838f
C120 VCP.n21 VSS 0.088368f
C121 VCP.n22 VSS 0.197554f
C122 VCP.t12 VSS 0.040838f
C123 VCP.t7 VSS 0.040838f
C124 VCP.n23 VSS 0.088368f
C125 VCP.n24 VSS 0.107022f
C126 VDD.n0 VSS 2.57284f
C127 VDD.n1 VSS 0.033407f
C128 VDD.n2 VSS 0.413189f
C129 VDD.n3 VSS 0.413189f
C130 VDD.n4 VSS 0.028305f
C131 VDD.n5 VSS 0.413189f
C132 VDD.n6 VSS 0.033407f
C133 VDD.n7 VSS 0.413189f
C134 VDD.n8 VSS 0.413189f
C135 VDD.n9 VSS 0.033407f
C136 VDD.n10 VSS 0.413189f
C137 VDD.n11 VSS 0.413189f
C138 VDD.n12 VSS -0.13773f
C139 VDD.n13 VSS 0.413189f
C140 VDD.n14 VSS 0.267747f
C141 VDD.n15 VSS 0.060617f
C142 VDD.n16 VSS 0.413189f
C143 VDD.n17 VSS 0.260007f
C144 VDD.n18 VSS 0.060617f
C145 VDD.n19 VSS 0.259979f
C146 VDD.n20 VSS 0.413189f
C147 VDD.n21 VSS 0.413189f
C148 VDD.n22 VSS 0.413189f
C149 VDD.n23 VSS 0.259979f
C150 VDD.n24 VSS 0.033407f
C151 VDD.n25 VSS 0.849651f
C152 VDD.n26 VSS 0.028305f
C153 VDD.n27 VSS 0.259979f
C154 VDD.n28 VSS 0.033407f
C155 VDD.n29 VSS 0.033407f
C156 VDD.n30 VSS 0.259979f
C157 VDD.n31 VSS 0.413189f
C158 VDD.n32 VSS 0.413189f
C159 VDD.n33 VSS 0.413189f
C160 VDD.n34 VSS 0.259979f
C161 VDD.n35 VSS 0.033407f
C162 VDD.n36 VSS 0.413189f
C163 VDD.n37 VSS -0.13773f
C164 VDD.n38 VSS 0.267747f
C165 VDD.n39 VSS 0.060617f
C166 VDD.n40 VSS 0.259979f
C167 VDD.n41 VSS 0.084915f
C168 VDD.n42 VSS 6.89713f
C169 m1_3236_1400# VSS 1.434686f
C170 VIP VSS 0.560067f
C171 m1_2150_1400# VSS 1.831731f
C172 m1_2838_1316# VSS 2.737683f
C173 VIN VSS 0.563099f
C174 IB VSS 3.822309f
C175 m1_4526_1568# VSS 0.699687f
C176 m1_914_1568# VSS 0.666665f
C177 VDD VSS 48.123974f
C178 VCN VSS 5.600637f
C179 m1_4010_1652# VSS 3.1229f
.ends
