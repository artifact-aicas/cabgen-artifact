* NGSPICE file created from TELESCOPIC_OTA_0.ext - technology: sky130A

.subckt PMOS_S_43132956_X9_Y1_1774869329 a_200_252# a_230_378# w_0_0#
X0 a_230_378# a_200_252# w_0_0# w_0_0# sky130_fd_pr__pfet_01v8 ad=0.2646 pd=2.17 as=0.2646 ps=2.17 w=1.89 l=0.15 M=18
.ends

.subckt NMOS_4T_91638993_X3_Y2_1774869327 a_200_252# a_230_378# a_147_378# a_241_2408#
X0 a_230_378# a_200_252# a_147_378# a_241_2408# sky130_fd_pr__nfet_01v8 ad=0.2646 pd=2.17 as=0.2646 ps=2.17 w=1.89 l=0.15 M=12
.ends

.subckt PMOS_4T_19330511_X7_Y1_1774869328 a_200_252# a_230_378# w_0_0# a_147_378#
X0 a_230_378# a_200_252# a_147_378# w_0_0# sky130_fd_pr__pfet_01v8 ad=0.2646 pd=2.17 as=0.2646 ps=2.17 w=1.89 l=0.15 M=14
.ends

.subckt SCM_NMOS_27386274_X2_Y1_1774869330 a_200_252# a_402_378# a_147_378#
X0 a_402_378# a_200_252# a_147_378# a_147_378# sky130_fd_pr__nfet_01v8 ad=0.2646 pd=2.17 as=0.2646 ps=2.17 w=1.89 l=0.15 M=4
X1 a_200_252# a_200_252# a_147_378# a_147_378# sky130_fd_pr__nfet_01v8 ad=0.2646 pd=2.17 as=0.2646 ps=2.17 w=1.89 l=0.15 M=4
.ends

.subckt NMOS_4T_36089430_X1_Y1_1774869326 a_200_252# a_230_378# a_147_378# a_241_1232#
X0 a_230_378# a_200_252# a_147_378# a_241_1232# sky130_fd_pr__nfet_01v8 ad=0.2646 pd=2.17 as=0.50085 ps=4.31 w=1.89 l=0.15 M=2
.ends

.subckt TELESCOPIC_OTA_0 IB VCN VOUT VIP VIN VCP VSS VDD
XPMOS_S_43132956_X9_Y1_1774869329_0 m1_4010_1652# m1_914_1568# VDD PMOS_S_43132956_X9_Y1_1774869329
XNMOS_4T_91638993_X3_Y2_1774869327_0 VCN VOUT m1_2150_1400# VSS NMOS_4T_91638993_X3_Y2_1774869327
XPMOS_S_43132956_X9_Y1_1774869329_1 m1_4010_1652# m1_4526_1568# VDD PMOS_S_43132956_X9_Y1_1774869329
XNMOS_4T_91638993_X3_Y2_1774869327_1 VCN m1_4010_1652# m1_3236_1400# VSS NMOS_4T_91638993_X3_Y2_1774869327
XPMOS_4T_19330511_X7_Y1_1774869328_0 VCP VOUT VDD m1_914_1568# PMOS_4T_19330511_X7_Y1_1774869328
XPMOS_4T_19330511_X7_Y1_1774869328_1 VCP m1_4010_1652# VDD m1_4526_1568# PMOS_4T_19330511_X7_Y1_1774869328
XSCM_NMOS_27386274_X2_Y1_1774869330_0 IB m1_2838_1316# VSS SCM_NMOS_27386274_X2_Y1_1774869330
XNMOS_4T_36089430_X1_Y1_1774869326_0 VIN m1_2150_1400# m1_2838_1316# VSS NMOS_4T_36089430_X1_Y1_1774869326
XNMOS_4T_36089430_X1_Y1_1774869326_1 VIP m1_3236_1400# m1_2838_1316# VSS NMOS_4T_36089430_X1_Y1_1774869326
.ends
