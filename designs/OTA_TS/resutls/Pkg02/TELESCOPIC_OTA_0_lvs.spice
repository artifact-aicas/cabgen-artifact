* NGSPICE file created from TELESCOPIC_OTA_0.ext - technology: sky130A

.subckt PMOS_4T_54671542_X3_Y1_1772448769 a_230_357# a_200_252# a_147_357# w_0_0#
X0 a_230_357# a_200_252# a_147_357# w_0_0# sky130_fd_pr__pfet_01v8 ad=0.294 pd=2.38 as=0.5565 ps=4.73 w=2.1 l=0.15 M=6
.ends

.subckt SCM_NMOS_4295876_X1_Y1_1772448771 a_200_252# a_402_357# a_147_357#
X0 a_200_252# a_200_252# a_147_357# a_147_357# sky130_fd_pr__nfet_01v8 ad=0.294 pd=2.38 as=0.5565 ps=4.73 w=2.1 l=0.15 M=2
X1 a_402_357# a_200_252# a_147_357# a_147_357# sky130_fd_pr__nfet_01v8 ad=0.294 pd=2.38 as=0.294 ps=2.38 w=2.1 l=0.15 M=2
.ends

.subckt NMOS_4T_2477428_X5_Y1_1772448768 a_230_357# a_200_252# a_147_357# a_241_1232#
X0 a_230_357# a_200_252# a_147_357# a_241_1232# sky130_fd_pr__nfet_01v8 ad=0.294 pd=2.38 as=0.294 ps=2.38 w=2.1 l=0.15 M=10
.ends

.subckt PMOS_S_62155954_X3_Y1_1772448770 a_230_357# a_200_252# w_0_0#
X0 a_230_357# a_200_252# w_0_0# w_0_0# sky130_fd_pr__pfet_01v8 ad=0.294 pd=2.38 as=0.5565 ps=4.73 w=2.1 l=0.15 M=6
.ends

.subckt TELESCOPIC_OTA_0 IB VCN VOUT VIP VIN VCP VSS VDD
XPMOS_4T_54671542_X3_Y1_1772448769_0 VOUT VCP m1_2290_1400# VDD PMOS_4T_54671542_X3_Y1_1772448769
XPMOS_4T_54671542_X3_Y1_1772448769_1 m1_3236_560# VCP m1_3150_1400# VDD PMOS_4T_54671542_X3_Y1_1772448769
XSCM_NMOS_4295876_X1_Y1_1772448771_0 IB m1_430_1316# VSS SCM_NMOS_4295876_X1_Y1_1772448771
XNMOS_4T_2477428_X5_Y1_1772448768_1 m1_4182_1400# VIP m1_430_1316# VSS NMOS_4T_2477428_X5_Y1_1772448768
XNMOS_4T_2477428_X5_Y1_1772448768_0 m1_1258_1400# VIN m1_430_1316# VSS NMOS_4T_2477428_X5_Y1_1772448768
XNMOS_4T_2477428_X5_Y1_1772448768_2 VOUT VCN m1_1258_1400# VSS NMOS_4T_2477428_X5_Y1_1772448768
XNMOS_4T_2477428_X5_Y1_1772448768_3 m1_3236_560# VCN m1_4182_1400# VSS NMOS_4T_2477428_X5_Y1_1772448768
XPMOS_S_62155954_X3_Y1_1772448770_0 m1_2290_1400# m1_3236_560# VDD PMOS_S_62155954_X3_Y1_1772448770
XPMOS_S_62155954_X3_Y1_1772448770_1 m1_3150_1400# m1_3236_560# VDD PMOS_S_62155954_X3_Y1_1772448770
.ends
