* NGSPICE file created from TELESCOPIC_OTA_0.ext - technology: sky130A

.subckt PMOS_4T_54671542_X3_Y1_1772448769 a_230_357# a_200_252# a_147_357# w_0_0#
+ VSUBS
X0 a_230_357# a_200_252# a_147_357# w_0_0# sky130_fd_pr__pfet_01v8 ad=0.294 pd=2.38 as=0.5565 ps=4.73 w=2.1 l=0.15
X1 a_147_357# a_200_252# a_230_357# w_0_0# sky130_fd_pr__pfet_01v8 ad=0.294 pd=2.38 as=0.294 ps=2.38 w=2.1 l=0.15
X2 a_147_357# a_200_252# a_230_357# w_0_0# sky130_fd_pr__pfet_01v8 ad=0.5565 pd=4.73 as=0.294 ps=2.38 w=2.1 l=0.15
X3 a_230_357# a_200_252# a_147_357# w_0_0# sky130_fd_pr__pfet_01v8 ad=0.294 pd=2.38 as=0.294 ps=2.38 w=2.1 l=0.15
X4 a_147_357# a_200_252# a_230_357# w_0_0# sky130_fd_pr__pfet_01v8 ad=0.294 pd=2.38 as=0.294 ps=2.38 w=2.1 l=0.15
X5 a_230_357# a_200_252# a_147_357# w_0_0# sky130_fd_pr__pfet_01v8 ad=0.294 pd=2.38 as=0.294 ps=2.38 w=2.1 l=0.15
C0 a_230_357# a_147_357# 2.05653f
C1 w_0_0# a_147_357# 0.238949f
C2 a_200_252# a_147_357# 0.229277f
C3 a_230_357# w_0_0# 0.088697f
C4 a_230_357# a_200_252# 0.236358f
C5 a_200_252# w_0_0# 0.8873f
C6 a_230_357# VSUBS 0.120105f
C7 a_147_357# VSUBS 0.275952f
C8 a_200_252# VSUBS 0.227458f
C9 w_0_0# VSUBS 4.03601f
.ends

.subckt SCM_NMOS_4295876_X1_Y1_1772448771 a_200_252# a_402_357# a_147_357#
X0 a_200_252# a_200_252# a_147_357# a_147_357# sky130_fd_pr__nfet_01v8 ad=0.294 pd=2.38 as=0.5565 ps=4.73 w=2.1 l=0.15
X1 a_147_357# a_200_252# a_200_252# a_147_357# sky130_fd_pr__nfet_01v8 ad=0.294 pd=2.38 as=0.294 ps=2.38 w=2.1 l=0.15
X2 a_402_357# a_200_252# a_147_357# a_147_357# sky130_fd_pr__nfet_01v8 ad=0.294 pd=2.38 as=0.294 ps=2.38 w=2.1 l=0.15
X3 a_147_357# a_200_252# a_402_357# a_147_357# sky130_fd_pr__nfet_01v8 ad=0.5565 pd=4.73 as=0.294 ps=2.38 w=2.1 l=0.15
C0 a_402_357# a_200_252# 0.169481f
C1 a_402_357# a_147_357# 0.888026f
C2 a_200_252# a_147_357# 2.29989f
.ends

.subckt NMOS_4T_2477428_X5_Y1_1772448768 a_230_357# a_200_252# a_147_357# a_241_1232#
X0 a_230_357# a_200_252# a_147_357# a_241_1232# sky130_fd_pr__nfet_01v8 ad=0.294 pd=2.38 as=0.294 ps=2.38 w=2.1 l=0.15
X1 a_147_357# a_200_252# a_230_357# a_241_1232# sky130_fd_pr__nfet_01v8 ad=0.5565 pd=4.73 as=0.294 ps=2.38 w=2.1 l=0.15
X2 a_230_357# a_200_252# a_147_357# a_241_1232# sky130_fd_pr__nfet_01v8 ad=0.294 pd=2.38 as=0.5565 ps=4.73 w=2.1 l=0.15
X3 a_147_357# a_200_252# a_230_357# a_241_1232# sky130_fd_pr__nfet_01v8 ad=0.294 pd=2.38 as=0.294 ps=2.38 w=2.1 l=0.15
X4 a_147_357# a_200_252# a_230_357# a_241_1232# sky130_fd_pr__nfet_01v8 ad=0.294 pd=2.38 as=0.294 ps=2.38 w=2.1 l=0.15
X5 a_230_357# a_200_252# a_147_357# a_241_1232# sky130_fd_pr__nfet_01v8 ad=0.294 pd=2.38 as=0.294 ps=2.38 w=2.1 l=0.15
X6 a_230_357# a_200_252# a_147_357# a_241_1232# sky130_fd_pr__nfet_01v8 ad=0.294 pd=2.38 as=0.294 ps=2.38 w=2.1 l=0.15
X7 a_147_357# a_200_252# a_230_357# a_241_1232# sky130_fd_pr__nfet_01v8 ad=0.294 pd=2.38 as=0.294 ps=2.38 w=2.1 l=0.15
X8 a_147_357# a_200_252# a_230_357# a_241_1232# sky130_fd_pr__nfet_01v8 ad=0.294 pd=2.38 as=0.294 ps=2.38 w=2.1 l=0.15
X9 a_230_357# a_200_252# a_147_357# a_241_1232# sky130_fd_pr__nfet_01v8 ad=0.294 pd=2.38 as=0.294 ps=2.38 w=2.1 l=0.15
C0 a_200_252# a_230_357# 0.394203f
C1 a_147_357# a_230_357# 3.47055f
C2 a_147_357# a_200_252# 0.390247f
C3 a_230_357# a_241_1232# 0.349772f
C4 a_147_357# a_241_1232# 0.600468f
C5 a_200_252# a_241_1232# 1.75062f
.ends

.subckt PMOS_S_62155954_X3_Y1_1772448770 a_230_357# a_200_252# w_0_0# VSUBS
X0 a_230_357# a_200_252# w_0_0# w_0_0# sky130_fd_pr__pfet_01v8 ad=0.294 pd=2.38 as=0.5565 ps=4.73 w=2.1 l=0.15
X1 w_0_0# a_200_252# a_230_357# w_0_0# sky130_fd_pr__pfet_01v8 ad=0.294 pd=2.38 as=0.294 ps=2.38 w=2.1 l=0.15
X2 w_0_0# a_200_252# a_230_357# w_0_0# sky130_fd_pr__pfet_01v8 ad=0.5565 pd=4.73 as=0.294 ps=2.38 w=2.1 l=0.15
X3 a_230_357# a_200_252# w_0_0# w_0_0# sky130_fd_pr__pfet_01v8 ad=0.294 pd=2.38 as=0.294 ps=2.38 w=2.1 l=0.15
X4 w_0_0# a_200_252# a_230_357# w_0_0# sky130_fd_pr__pfet_01v8 ad=0.294 pd=2.38 as=0.294 ps=2.38 w=2.1 l=0.15
X5 a_230_357# a_200_252# w_0_0# w_0_0# sky130_fd_pr__pfet_01v8 ad=0.294 pd=2.38 as=0.294 ps=2.38 w=2.1 l=0.15
C0 w_0_0# a_230_357# 2.19443f
C1 a_200_252# a_230_357# 0.236358f
C2 a_200_252# w_0_0# 1.22702f
C3 a_230_357# VSUBS 0.120105f
C4 a_200_252# VSUBS 0.227458f
C5 w_0_0# VSUBS 4.391819f
.ends

.subckt TELESCOPIC_OTA_0 IB VCN VOUT VIP VIN VCP VSS VDD
XPMOS_4T_54671542_X3_Y1_1772448769_0 VOUT VCP m1_2290_1400# VDD VSS PMOS_4T_54671542_X3_Y1_1772448769
XPMOS_4T_54671542_X3_Y1_1772448769_1 m1_3236_560# VCP m1_3150_1400# VDD VSS PMOS_4T_54671542_X3_Y1_1772448769
XSCM_NMOS_4295876_X1_Y1_1772448771_0 IB m1_430_1316# VSS SCM_NMOS_4295876_X1_Y1_1772448771
XNMOS_4T_2477428_X5_Y1_1772448768_1 m1_4182_1400# VIP m1_430_1316# VSS NMOS_4T_2477428_X5_Y1_1772448768
XNMOS_4T_2477428_X5_Y1_1772448768_0 m1_1258_1400# VIN m1_430_1316# VSS NMOS_4T_2477428_X5_Y1_1772448768
XNMOS_4T_2477428_X5_Y1_1772448768_2 VOUT VCN m1_1258_1400# VSS NMOS_4T_2477428_X5_Y1_1772448768
XNMOS_4T_2477428_X5_Y1_1772448768_3 m1_3236_560# VCN m1_4182_1400# VSS NMOS_4T_2477428_X5_Y1_1772448768
XPMOS_S_62155954_X3_Y1_1772448770_0 m1_2290_1400# m1_3236_560# VDD VSS PMOS_S_62155954_X3_Y1_1772448770
XPMOS_S_62155954_X3_Y1_1772448770_1 m1_3150_1400# m1_3236_560# VDD VSS PMOS_S_62155954_X3_Y1_1772448770
R0 VCP.n8 VCP.t2 568.582
R1 VCP.n8 VCP.t5 568.582
R2 VCP.n7 VCP.t4 568.582
R3 VCP.n7 VCP.t3 568.582
R4 VCP.n5 VCP.t1 568.582
R5 VCP.n5 VCP.t0 568.582
R6 VCP.n3 VCP.t6 568.582
R7 VCP.n3 VCP.t7 568.582
R8 VCP.n1 VCP.t9 568.582
R9 VCP.n1 VCP.t10 568.582
R10 VCP.n0 VCP.t11 568.582
R11 VCP.n0 VCP.t8 568.582
R12 VCP VCP.n8 161.685
R13 VCP.n2 VCP.n0 161.685
R14 VCP VCP.n7 161.3
R15 VCP.n6 VCP.n5 161.3
R16 VCP.n4 VCP.n3 161.3
R17 VCP.n2 VCP.n1 161.3
R18 VCP.n6 VCP.n4 1.15229
R19 VCP.n4 VCP.n2 0.384429
R20 VCP VCP.n6 0.384429
R21 IB.n2 IB.t2 294.913
R22 IB.n2 IB.t0 294.913
R23 IB.n1 IB.t4 294.913
R24 IB.n1 IB.t5 294.913
R25 IB.n3 IB.n1 161.685
R26 IB.n3 IB.n2 161.3
R27 IB IB.n0 147.46
R28 IB.n0 IB.t1 8.0005
R29 IB.n0 IB.t3 8.0005
R30 IB IB.n3 5.438
R31 VSS.n36 VSS.n0 65516.6
R32 VSS.n25 VSS.n0 1179.68
R33 VSS.n16 VSS.n15 1179.68
R34 VSS.n34 VSS.n33 1179.49
R35 VSS.n17 VSS.n16 1179.3
R36 VSS.n29 VSS.n28 1179.3
R37 VSS.n30 VSS.n2 1179.3
R38 VSS.n26 VSS.n25 1179.3
R39 VSS.n29 VSS.n24 1179.3
R40 VSS.n31 VSS.n30 1179.3
R41 VSS.n33 VSS.n32 1179.3
R42 VSS.n10 VSS.n6 840.539
R43 VSS.n11 VSS.n5 840.347
R44 VSS.n28 VSS.n27 535.494
R45 VSS.n29 VSS.n26 240.867
R46 VSS.n30 VSS.n29 240.867
R47 VSS.n30 VSS.n3 180.649
R48 VSS.n23 VSS.n22 120.433
R49 VSS.n22 VSS.n21 120.433
R50 VSS.n21 VSS.n20 120.433
R51 VSS.n20 VSS.n19 120.433
R52 VSS.n19 VSS.n18 120.433
R53 VSS.n13 VSS.n4 120.433
R54 VSS.n27 VSS.n0 109.294
R55 VSS.n27 VSS.n26 109.258
R56 VSS.n10 VSS.n9 99.0144
R57 VSS.n33 VSS.n3 60.2169
R58 VSS.n33 VSS.n23 60.2169
R59 VSS.n18 VSS.n17 60.2169
R60 VSS.n17 VSS.n4 60.2169
R61 VSS.n15 VSS.n13 60.2169
R62 VSS.n15 VSS.n14 60.2169
R63 VSS.n35 VSS.n34 11.473
R64 VSS.n32 VSS.n1 10.348
R65 VSS.n9 VSS.n7 8.0005
R66 VSS.n9 VSS.n8 8.0005
R67 VSS.n16 VSS.n12 6.938
R68 VSS.n12 VSS.n11 4.5005
R69 VSS VSS.n1 4.12458
R70 VSS VSS.n36 3.58615
R71 VSS.n12 VSS 0.563
R72 VSS.n36 VSS.n35 0.39295
R73 VSS.n25 VSS.n24 0.384429
R74 VSS.n31 VSS.n24 0.384429
R75 VSS.n32 VSS.n31 0.384429
R76 VSS.n28 VSS.n2 0.384429
R77 VSS.n11 VSS.n10 0.192464
R78 VSS.n34 VSS.n2 0.192464
R79 VSS.n35 VSS.n1 0.0257625
R80 VIP.n4 VIP.t3 568.582
R81 VIP.n4 VIP.t2 568.582
R82 VIP.n5 VIP.t7 568.582
R83 VIP.n5 VIP.t5 568.582
R84 VIP.n3 VIP.t4 568.582
R85 VIP.n3 VIP.t0 568.582
R86 VIP.n1 VIP.t8 568.582
R87 VIP.n1 VIP.t6 568.582
R88 VIP.n0 VIP.t1 568.582
R89 VIP.n0 VIP.t9 568.582
R90 VIP.n6 VIP.n4 161.685
R91 VIP.n2 VIP.n0 161.685
R92 VIP.n6 VIP.n5 161.3
R93 VIP VIP.n3 161.3
R94 VIP.n2 VIP.n1 161.3
R95 VIP VIP.n2 0.384429
R96 VIP VIP.n6 0.384429
R97 VIN.n5 VIN.t6 568.582
R98 VIN.n5 VIN.t8 568.582
R99 VIN.n3 VIN.t0 568.582
R100 VIN.n3 VIN.t4 568.582
R101 VIN.n1 VIN.t5 568.582
R102 VIN.n1 VIN.t7 568.582
R103 VIN.n0 VIN.t2 568.582
R104 VIN.n0 VIN.t3 568.582
R105 VIN.n4 VIN.t1 294.913
R106 VIN.n4 VIN.t9 294.913
R107 VIN.n6 VIN.n4 161.685
R108 VIN.n2 VIN.n0 161.685
R109 VIN.n6 VIN.n5 161.3
R110 VIN VIN.n3 161.3
R111 VIN.n2 VIN.n1 161.3
R112 VIN VIN.n2 0.384429
R113 VIN VIN.n6 0.384429
R114 VCN.n14 VCN.t2 568.582
R115 VCN.n14 VCN.t3 568.582
R116 VCN.n15 VCN.t5 568.582
R117 VCN.n15 VCN.t7 568.582
R118 VCN.n13 VCN.t0 568.582
R119 VCN.n13 VCN.t4 568.582
R120 VCN.n11 VCN.t6 568.582
R121 VCN.n11 VCN.t8 568.582
R122 VCN.n9 VCN.t9 568.582
R123 VCN.n9 VCN.t1 568.582
R124 VCN.n7 VCN.t11 568.582
R125 VCN.n7 VCN.t19 568.582
R126 VCN.n5 VCN.t18 568.582
R127 VCN.n5 VCN.t16 568.582
R128 VCN.n3 VCN.t14 568.582
R129 VCN.n3 VCN.t10 568.582
R130 VCN.n1 VCN.t17 568.582
R131 VCN.n1 VCN.t15 568.582
R132 VCN.n0 VCN.t13 568.582
R133 VCN.n0 VCN.t12 568.582
R134 VCN.n16 VCN.n14 161.685
R135 VCN.n2 VCN.n0 161.685
R136 VCN.n16 VCN.n15 161.3
R137 VCN VCN.n13 161.3
R138 VCN.n12 VCN.n11 161.3
R139 VCN.n10 VCN.n9 161.3
R140 VCN.n8 VCN.n7 161.3
R141 VCN.n6 VCN.n5 161.3
R142 VCN.n4 VCN.n3 161.3
R143 VCN.n2 VCN.n1 161.3
R144 VCN.n10 VCN.n8 85.1996
R145 VCN.n4 VCN.n2 0.384429
R146 VCN.n6 VCN.n4 0.384429
R147 VCN.n8 VCN.n6 0.384429
R148 VCN.n12 VCN.n10 0.384429
R149 VCN VCN.n12 0.384429
R150 VCN VCN.n16 0.384429
C0 VIP m1_4182_1400# 0.001474f
C1 VOUT m1_2290_1400# 0.258205f
C2 m1_430_1316# VCP 4.3e-19
C3 VOUT m1_3236_560# 0.00614f
C4 m1_1258_1400# VCN 0.013557f
C5 VDD VIP 0.101165f
C6 m1_4182_1400# m1_3236_560# 0.373553f
C7 VDD IB 0.078068f
C8 VCN m1_3150_1400# 0.088803f
C9 VCP VOUT -0.015767f
C10 VDD m1_2290_1400# 0.364372f
C11 VCN VIN 0.009524f
C12 VDD m1_3236_560# 1.365763f
C13 VCP m1_4182_1400# 2.99e-19
C14 m1_430_1316# VOUT 0.063133f
C15 m1_1258_1400# IB 0.003678f
C16 m1_1258_1400# m1_2290_1400# 0.068773f
C17 VCP VDD 0.275016f
C18 m1_430_1316# m1_4182_1400# 0.069086f
C19 m1_2290_1400# m1_3150_1400# 0.089492f
C20 IB VIN 0.027605f
C21 m1_3236_560# m1_3150_1400# 0.443388f
C22 m1_430_1316# VDD 1.695332f
C23 VCP m1_1258_1400# 2.99e-19
C24 m1_3236_560# VIN 0.027605f
C25 VCP m1_3150_1400# -0.03362f
C26 VOUT VDD 0.18797f
C27 m1_430_1316# m1_1258_1400# 0.069242f
C28 VIP VCN 0.009524f
C29 VDD m1_4182_1400# 0.104862f
C30 m1_430_1316# m1_3150_1400# 0.091226f
C31 m1_430_1316# VIN 0.001722f
C32 VOUT m1_1258_1400# 0.374959f
C33 m1_2290_1400# VCN 0.088803f
C34 VCN m1_3236_560# 0.048178f
C35 VOUT m1_3150_1400# 6.64e-19
C36 VOUT VIN 0.002052f
C37 m1_4182_1400# m1_3150_1400# 0.068523f
C38 VCP VCN 1.07178f
C39 VDD m1_1258_1400# 0.109849f
C40 VIP m1_3236_560# 0.029657f
C41 VDD m1_3150_1400# 0.277788f
C42 m1_430_1316# VCN 0.013011f
C43 m1_2290_1400# m1_3236_560# 0.001408f
C44 VDD VIN 0.090999f
C45 VOUT VCN 0.048084f
C46 VCP m1_2290_1400# -0.03362f
C47 m1_430_1316# VIP 0.001722f
C48 VCP m1_3236_560# -0.004262f
C49 m1_1258_1400# VIN 0.001474f
C50 m1_430_1316# IB -0.003473f
C51 m1_4182_1400# VCN 0.013557f
C52 m1_430_1316# m1_2290_1400# 0.091226f
C53 m1_430_1316# m1_3236_560# 0.275683f
C54 VDD VCN 0.424997f
C55 m1_3236_560# VSS 0.88512f
C56 VCP VSS 0.599252f
C57 m1_430_1316# VSS 2.564474f
C58 VCN VSS 4.048386f
C59 VCP.t8 VSS 0.052557f
C60 VCP.t11 VSS 0.052557f
C61 VCP.n0 VSS 0.097238f
C62 VCP.t10 VSS 0.052557f
C63 VCP.t9 VSS 0.052557f
C64 VCP.n1 VSS 0.097001f
C65 VCP.n2 VSS 0.216853f
C66 VCP.t7 VSS 0.052557f
C67 VCP.t6 VSS 0.052557f
C68 VCP.n3 VSS 0.097001f
C69 VCP.n4 VSS 0.176566f
C70 VCP.t0 VSS 0.052557f
C71 VCP.t1 VSS 0.052557f
C72 VCP.n5 VSS 0.097001f
C73 VCP.n6 VSS 0.176566f
C74 VCP.t3 VSS 0.052557f
C75 VCP.t4 VSS 0.052557f
C76 VCP.n7 VSS 0.097001f
C77 VCP.t5 VSS 0.052557f
C78 VCP.t2 VSS 0.052557f
C79 VCP.n8 VSS 0.097238f
C80 m1_1258_1400# VSS 1.142977f
C81 VIN VSS 1.842934f
C82 m1_4182_1400# VSS 1.149254f
C83 VIP VSS 1.851989f
C84 IB VSS 2.317699f
C85 m1_3150_1400# VSS 0.18799f
C86 VOUT VSS 6.566244f
C87 m1_2290_1400# VSS 0.224936f
C88 VDD VSS 32.746323f
.ends
