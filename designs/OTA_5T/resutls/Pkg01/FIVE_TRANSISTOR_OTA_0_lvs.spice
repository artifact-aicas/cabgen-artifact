* NGSPICE file created from FIVE_TRANSISTOR_OTA_0.ext - technology: sky130A

.subckt SCM_PMOS_9165244_X2_Y1_1772456889 a_200_252# a_402_357# w_0_0#
X0 a_200_252# a_200_252# w_0_0# w_0_0# sky130_fd_pr__pfet_01v8 ad=0.294 pd=2.38 as=0.5565 ps=4.73 w=2.1 l=0.15 M=4
X1 w_0_0# a_200_252# a_402_357# w_0_0# sky130_fd_pr__pfet_01v8 ad=0.294 pd=2.38 as=0.294 ps=2.38 w=2.1 l=0.15 M=4
.ends

.subckt SCM_NMOS_4295876_X1_Y1_1772456888 a_200_252# a_402_357# a_147_357#
X0 a_200_252# a_200_252# a_147_357# a_147_357# sky130_fd_pr__nfet_01v8 ad=0.294 pd=2.38 as=0.5565 ps=4.73 w=2.1 l=0.15 M=2
X1 a_402_357# a_200_252# a_147_357# a_147_357# sky130_fd_pr__nfet_01v8 ad=0.294 pd=2.38 as=0.294 ps=2.38 w=2.1 l=0.15 M=2
.ends

.subckt DP_NMOS_B_4373767_X2_Y1_1772456887 a_372_252# a_230_357# a_200_252# a_402_357#
+ a_147_357# a_241_1232#
X0 a_402_357# a_372_252# a_147_357# a_241_1232# sky130_fd_pr__nfet_01v8 ad=0.294 pd=2.38 as=0.294 ps=2.38 w=2.1 l=0.15 M=4
X1 a_230_357# a_200_252# a_147_357# a_241_1232# sky130_fd_pr__nfet_01v8 ad=0.294 pd=2.38 as=0.5565 ps=4.73 w=2.1 l=0.15 M=4
.ends

.subckt FIVE_TRANSISTOR_OTA_0 IB VSS VOUT VDD VIP VIN
XSCM_PMOS_9165244_X2_Y1_1772456889_0 li_1007_n17# VOUT VDD SCM_PMOS_9165244_X2_Y1_1772456889
XSCM_NMOS_4295876_X1_Y1_1772456888_0 IB li_1953_151# VSS SCM_NMOS_4295876_X1_Y1_1772456888
XDP_NMOS_B_4373767_X2_Y1_1772456887_0 VIN li_1007_n17# VIP VOUT li_1953_151# VSS DP_NMOS_B_4373767_X2_Y1_1772456887
.ends
