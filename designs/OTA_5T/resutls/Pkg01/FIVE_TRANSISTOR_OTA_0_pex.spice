* NGSPICE file created from FIVE_TRANSISTOR_OTA_0.ext - technology: sky130A

.subckt SCM_PMOS_9165244_X2_Y1_1772456889 a_200_252# a_402_357# w_0_0# VSUBS
X0 a_200_252# a_200_252# w_0_0# w_0_0# sky130_fd_pr__pfet_01v8 ad=0.294 pd=2.38 as=0.5565 ps=4.73 w=2.1 l=0.15
X1 w_0_0# a_200_252# a_200_252# w_0_0# sky130_fd_pr__pfet_01v8 ad=0.294 pd=2.38 as=0.294 ps=2.38 w=2.1 l=0.15
X2 w_0_0# a_200_252# a_402_357# w_0_0# sky130_fd_pr__pfet_01v8 ad=0.294 pd=2.38 as=0.294 ps=2.38 w=2.1 l=0.15
X3 a_402_357# a_200_252# w_0_0# w_0_0# sky130_fd_pr__pfet_01v8 ad=0.294 pd=2.38 as=0.294 ps=2.38 w=2.1 l=0.15
X4 a_200_252# a_200_252# w_0_0# w_0_0# sky130_fd_pr__pfet_01v8 ad=0.294 pd=2.38 as=0.294 ps=2.38 w=2.1 l=0.15
X5 w_0_0# a_200_252# a_402_357# w_0_0# sky130_fd_pr__pfet_01v8 ad=0.294 pd=2.38 as=0.294 ps=2.38 w=2.1 l=0.15
X6 w_0_0# a_200_252# a_200_252# w_0_0# sky130_fd_pr__pfet_01v8 ad=0.5565 pd=4.73 as=0.294 ps=2.38 w=2.1 l=0.15
X7 a_402_357# a_200_252# w_0_0# w_0_0# sky130_fd_pr__pfet_01v8 ad=0.294 pd=2.38 as=0.294 ps=2.38 w=2.1 l=0.15
C0 a_200_252# w_0_0# 3.39817f
C1 a_200_252# a_402_357# 0.385575f
C2 a_402_357# w_0_0# 1.4493f
C3 a_402_357# VSUBS 0.028413f
C4 a_200_252# VSUBS 0.529011f
C5 w_0_0# VSUBS 5.05811f
.ends

.subckt SCM_NMOS_4295876_X1_Y1_1772456888 a_200_252# a_402_357# a_147_357#
X0 a_200_252# a_200_252# a_147_357# a_147_357# sky130_fd_pr__nfet_01v8 ad=0.294 pd=2.38 as=0.5565 ps=4.73 w=2.1 l=0.15
X1 a_147_357# a_200_252# a_200_252# a_147_357# sky130_fd_pr__nfet_01v8 ad=0.294 pd=2.38 as=0.294 ps=2.38 w=2.1 l=0.15
X2 a_402_357# a_200_252# a_147_357# a_147_357# sky130_fd_pr__nfet_01v8 ad=0.294 pd=2.38 as=0.294 ps=2.38 w=2.1 l=0.15
X3 a_147_357# a_200_252# a_402_357# a_147_357# sky130_fd_pr__nfet_01v8 ad=0.5565 pd=4.73 as=0.294 ps=2.38 w=2.1 l=0.15
C0 a_402_357# a_200_252# 0.169481f
C1 a_402_357# a_147_357# 0.888026f
C2 a_200_252# a_147_357# 2.29989f
.ends

.subckt DP_NMOS_B_4373767_X2_Y1_1772456887 a_372_252# a_230_357# a_200_252# a_402_357#
+ a_147_357# a_241_1232#
X0 a_402_357# a_372_252# a_147_357# a_241_1232# sky130_fd_pr__nfet_01v8 ad=0.294 pd=2.38 as=0.294 ps=2.38 w=2.1 l=0.15
X1 a_230_357# a_200_252# a_147_357# a_241_1232# sky130_fd_pr__nfet_01v8 ad=0.294 pd=2.38 as=0.5565 ps=4.73 w=2.1 l=0.15
X2 a_147_357# a_200_252# a_230_357# a_241_1232# sky130_fd_pr__nfet_01v8 ad=0.294 pd=2.38 as=0.294 ps=2.38 w=2.1 l=0.15
X3 a_147_357# a_372_252# a_402_357# a_241_1232# sky130_fd_pr__nfet_01v8 ad=0.294 pd=2.38 as=0.294 ps=2.38 w=2.1 l=0.15
X4 a_402_357# a_372_252# a_147_357# a_241_1232# sky130_fd_pr__nfet_01v8 ad=0.294 pd=2.38 as=0.294 ps=2.38 w=2.1 l=0.15
X5 a_230_357# a_200_252# a_147_357# a_241_1232# sky130_fd_pr__nfet_01v8 ad=0.294 pd=2.38 as=0.294 ps=2.38 w=2.1 l=0.15
X6 a_147_357# a_372_252# a_402_357# a_241_1232# sky130_fd_pr__nfet_01v8 ad=0.294 pd=2.38 as=0.294 ps=2.38 w=2.1 l=0.15
X7 a_147_357# a_200_252# a_230_357# a_241_1232# sky130_fd_pr__nfet_01v8 ad=0.5565 pd=4.73 as=0.294 ps=2.38 w=2.1 l=0.15
C0 a_372_252# a_230_357# 0.001051f
C1 a_372_252# a_200_252# 0.47069f
C2 a_372_252# a_402_357# 0.146999f
C3 a_230_357# a_200_252# 0.157118f
C4 a_402_357# a_230_357# 0.166756f
C5 a_402_357# a_200_252# 0.01033f
C6 a_372_252# a_147_357# 0.136019f
C7 a_230_357# a_147_357# 1.35788f
C8 a_147_357# a_200_252# 0.192638f
C9 a_402_357# a_147_357# 1.35771f
C10 a_402_357# a_241_1232# 0.085996f
C11 a_230_357# a_241_1232# 0.219939f
C12 a_147_357# a_241_1232# 0.547018f
C13 a_372_252# a_241_1232# 0.634944f
C14 a_200_252# a_241_1232# 0.829344f
.ends

.subckt FIVE_TRANSISTOR_OTA_0 IB VSS VOUT VDD VIP VIN
XSCM_PMOS_9165244_X2_Y1_1772456889_0 li_1007_n17# VOUT VDD VSS SCM_PMOS_9165244_X2_Y1_1772456889
XSCM_NMOS_4295876_X1_Y1_1772456888_0 IB li_1953_151# VSS SCM_NMOS_4295876_X1_Y1_1772456888
XDP_NMOS_B_4373767_X2_Y1_1772456887_0 VIN li_1007_n17# VIP VOUT li_1953_151# VSS DP_NMOS_B_4373767_X2_Y1_1772456887
R0 VDD.n1 VDD.n0 379.685
R1 VDD.n5 VDD.n4 379.685
R2 VDD.n2 VDD.n0 379.3
R3 VDD.n5 VDD.n3 379.3
R4 VDD.n11 VDD.t3 194.764
R5 VDD.n7 VDD.t15 194.764
R6 VDD.n11 VDD.n10 181.248
R7 VDD.n9 VDD.n8 181.248
R8 VDD.n7 VDD.n6 181.248
R9 VDD.t8 VDD.t12 54.0349
R10 VDD.t0 VDD.t4 54.0349
R11 VDD.t6 VDD.t10 54.0349
R12 VDD.n1 VDD.t14 27.0177
R13 VDD.t12 VDD.n1 27.0177
R14 VDD.n2 VDD.t8 27.0177
R15 VDD.t4 VDD.n2 27.0177
R16 VDD.n3 VDD.t0 27.0177
R17 VDD.t10 VDD.n3 27.0177
R18 VDD.n4 VDD.t6 27.0177
R19 VDD.n4 VDD.t2 27.0177
R20 VDD.n10 VDD.t11 13.1338
R21 VDD.n10 VDD.t7 13.1338
R22 VDD.n8 VDD.t5 13.1338
R23 VDD.n8 VDD.t1 13.1338
R24 VDD.n6 VDD.t13 13.1338
R25 VDD.n6 VDD.t9 13.1338
R26 VDD VDD.n5 5.71925
R27 VDD VDD.n12 5.71925
R28 VDD.n5 VDD.n0 0.384429
R29 VDD.n9 VDD.n7 0.384429
R30 VDD.n12 VDD.n9 0.192464
R31 VDD.n12 VDD.n11 0.192464
R32 VOUT VOUT.n1 202.944
R33 VOUT VOUT.n0 202.944
R34 VOUT.n1 VOUT.t0 13.1338
R35 VOUT.n1 VOUT.t3 13.1338
R36 VOUT.n0 VOUT.t2 13.1338
R37 VOUT.n0 VOUT.t1 13.1338
R38 IB.n1 IB.t5 568.582
R39 IB.n1 IB.t4 568.582
R40 IB.n0 IB.t0 568.582
R41 IB.n0 IB.t2 568.582
R42 IB.n2 IB.n1 161.685
R43 IB.n2 IB.n0 161.3
R44 IB IB.n3 147.459
R45 IB.n3 IB.t3 8.0005
R46 IB.n3 IB.t1 8.0005
R47 IB IB.n2 5.438
R48 VIN.n1 VIN.t2 568.582
R49 VIN.n1 VIN.t3 568.582
R50 VIN.n0 VIN.t0 568.582
R51 VIN.n0 VIN.t1 568.582
R52 VIN VIN.n1 182.996
R53 VIN VIN.n0 182.996
R54 VIP.n1 VIP.t0 568.582
R55 VIP.n1 VIP.t1 568.582
R56 VIP.n0 VIP.t2 568.582
R57 VIP.n0 VIP.t3 568.582
R58 VIP VIP.n1 161.876
R59 VIP VIP.n0 161.876
C0 VSS IB 0.001935f
C1 VDD li_1953_151# 0.091547f
C2 IB li_1953_151# 0.005471f
C3 IB VDD 4.14e-19
C4 VIP VOUT 7.06e-19
C5 VIN VOUT 2.8e-19
C6 VIP li_1007_n17# 0.033655f
C7 VIN li_1007_n17# 0.00455f
C8 VIP VSS 0.010778f
C9 VIN VSS 0.006748f
C10 VOUT li_1007_n17# 0.449014f
C11 VSS VOUT 0.00363f
C12 VIP li_1953_151# 6.08e-19
C13 VSS li_1007_n17# 0.006537f
C14 VOUT li_1953_151# 0.19012f
C15 VIP VDD 0.021267f
C16 VIN VDD 0.003477f
C17 VIP IB 0.027605f
C18 VIN IB 1.4e-19
C19 li_1953_151# li_1007_n17# -0.028035f
C20 VSS li_1953_151# 0.169276f
C21 VDD VOUT 0.222348f
C22 IB VOUT 7.86e-19
C23 VDD li_1007_n17# -0.004314f
C24 IB li_1007_n17# 0.004993f
C25 VSS VDD 0.037798f
C26 VSS 0 -0.023869f
C27 VDD.n0 0 0.048604f
C28 VDD.t14 0 0.607391f
C29 VDD.n1 0 0.104251f
C30 VDD.t12 0 0.165652f
C31 VDD.t8 0 0.165652f
C32 VDD.n2 0 0.104229f
C33 VDD.t4 0 0.165652f
C34 VDD.t0 0 0.165652f
C35 VDD.n3 0 0.104229f
C36 VDD.t10 0 0.165652f
C37 VDD.t6 0 0.165652f
C38 VDD.t2 0 0.607391f
C39 VDD.n4 0 0.104251f
C40 VDD.n5 0 0.054787f
C41 VDD.t15 0 0.049898f
C42 VDD.t13 0 0.009988f
C43 VDD.t9 0 0.009988f
C44 VDD.n6 0 0.034829f
C45 VDD.n7 0 0.120753f
C46 VDD.t5 0 0.009988f
C47 VDD.t1 0 0.009988f
C48 VDD.n8 0 0.034829f
C49 VDD.n9 0 0.057376f
C50 VDD.t3 0 0.049898f
C51 VDD.t11 0 0.009988f
C52 VDD.t7 0 0.009988f
C53 VDD.n10 0 0.034829f
C54 VDD.n11 0 0.116663f
C55 VDD.n12 0 0.014363f
C56 VOUT 0 0.138272f
C57 li_1007_n17# 0 0.846732f
C58 li_1953_151# 0 1.377178f
C59 VIN 0 0.630927f
C60 VIP 0 0.746686f
C61 IB 0 2.254458f
C62 VDD 0 5.04978f
.ends
