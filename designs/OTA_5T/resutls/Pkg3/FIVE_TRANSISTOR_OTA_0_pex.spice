* NGSPICE file created from FIVE_TRANSISTOR_OTA_0.ext - technology: sky130A

.subckt PMOS_S_21674997_X6_Y1_1774868989 a_200_252# w_0_0# a_230_525# VSUBS
X0 w_0_0# a_200_252# a_230_525# w_0_0# sky130_fd_pr__pfet_01v8 ad=0.1113 pd=1.37 as=0.0588 ps=0.7 w=0.42 l=0.15
X1 w_0_0# a_200_252# a_230_525# w_0_0# sky130_fd_pr__pfet_01v8 ad=0.0588 pd=0.7 as=0.0588 ps=0.7 w=0.42 l=0.15
X2 w_0_0# a_200_252# a_230_525# w_0_0# sky130_fd_pr__pfet_01v8 ad=0.0588 pd=0.7 as=0.0588 ps=0.7 w=0.42 l=0.15
X3 a_230_525# a_200_252# w_0_0# w_0_0# sky130_fd_pr__pfet_01v8 ad=0.0588 pd=0.7 as=0.0588 ps=0.7 w=0.42 l=0.15
X4 a_230_525# a_200_252# w_0_0# w_0_0# sky130_fd_pr__pfet_01v8 ad=0.0588 pd=0.7 as=0.0588 ps=0.7 w=0.42 l=0.15
X5 w_0_0# a_200_252# a_230_525# w_0_0# sky130_fd_pr__pfet_01v8 ad=0.0588 pd=0.7 as=0.0588 ps=0.7 w=0.42 l=0.15
X6 a_230_525# a_200_252# w_0_0# w_0_0# sky130_fd_pr__pfet_01v8 ad=0.0588 pd=0.7 as=0.1113 ps=1.37 w=0.42 l=0.15
X7 w_0_0# a_200_252# a_230_525# w_0_0# sky130_fd_pr__pfet_01v8 ad=0.0588 pd=0.7 as=0.0588 ps=0.7 w=0.42 l=0.15
X8 w_0_0# a_200_252# a_230_525# w_0_0# sky130_fd_pr__pfet_01v8 ad=0.0588 pd=0.7 as=0.0588 ps=0.7 w=0.42 l=0.15
X9 a_230_525# a_200_252# w_0_0# w_0_0# sky130_fd_pr__pfet_01v8 ad=0.0588 pd=0.7 as=0.0588 ps=0.7 w=0.42 l=0.15
X10 a_230_525# a_200_252# w_0_0# w_0_0# sky130_fd_pr__pfet_01v8 ad=0.0588 pd=0.7 as=0.0588 ps=0.7 w=0.42 l=0.15
X11 a_230_525# a_200_252# w_0_0# w_0_0# sky130_fd_pr__pfet_01v8 ad=0.0588 pd=0.7 as=0.0588 ps=0.7 w=0.42 l=0.15
C0 a_200_252# a_230_525# 0.607585f
C1 a_200_252# w_0_0# 3.62811f
C2 a_230_525# w_0_0# 4.515759f
C3 a_230_525# VSUBS 0.244237f
C4 a_200_252# VSUBS 0.403617f
C5 w_0_0# VSUBS 6.63738f
.ends

.subckt DCL_PMOS_S_80097108_X6_Y1_1774868987 a_200_252# w_0_0# VSUBS
X0 w_0_0# a_200_252# a_200_252# w_0_0# sky130_fd_pr__pfet_01v8 ad=0.1113 pd=1.37 as=0.0588 ps=0.7 w=0.42 l=0.15
X1 w_0_0# a_200_252# a_200_252# w_0_0# sky130_fd_pr__pfet_01v8 ad=0.0588 pd=0.7 as=0.0588 ps=0.7 w=0.42 l=0.15
X2 w_0_0# a_200_252# a_200_252# w_0_0# sky130_fd_pr__pfet_01v8 ad=0.0588 pd=0.7 as=0.0588 ps=0.7 w=0.42 l=0.15
X3 a_200_252# a_200_252# w_0_0# w_0_0# sky130_fd_pr__pfet_01v8 ad=0.0588 pd=0.7 as=0.0588 ps=0.7 w=0.42 l=0.15
X4 a_200_252# a_200_252# w_0_0# w_0_0# sky130_fd_pr__pfet_01v8 ad=0.0588 pd=0.7 as=0.0588 ps=0.7 w=0.42 l=0.15
X5 w_0_0# a_200_252# a_200_252# w_0_0# sky130_fd_pr__pfet_01v8 ad=0.0588 pd=0.7 as=0.0588 ps=0.7 w=0.42 l=0.15
X6 a_200_252# a_200_252# w_0_0# w_0_0# sky130_fd_pr__pfet_01v8 ad=0.0588 pd=0.7 as=0.1113 ps=1.37 w=0.42 l=0.15
X7 w_0_0# a_200_252# a_200_252# w_0_0# sky130_fd_pr__pfet_01v8 ad=0.0588 pd=0.7 as=0.0588 ps=0.7 w=0.42 l=0.15
X8 w_0_0# a_200_252# a_200_252# w_0_0# sky130_fd_pr__pfet_01v8 ad=0.0588 pd=0.7 as=0.0588 ps=0.7 w=0.42 l=0.15
X9 a_200_252# a_200_252# w_0_0# w_0_0# sky130_fd_pr__pfet_01v8 ad=0.0588 pd=0.7 as=0.0588 ps=0.7 w=0.42 l=0.15
X10 a_200_252# a_200_252# w_0_0# w_0_0# sky130_fd_pr__pfet_01v8 ad=0.0588 pd=0.7 as=0.0588 ps=0.7 w=0.42 l=0.15
X11 a_200_252# a_200_252# w_0_0# w_0_0# sky130_fd_pr__pfet_01v8 ad=0.0588 pd=0.7 as=0.0588 ps=0.7 w=0.42 l=0.15
C0 a_200_252# w_0_0# 8.68013f
C1 a_200_252# VSUBS 0.731955f
C2 w_0_0# VSUBS 6.64063f
.ends

.subckt NMOS_4T_66219913_X4_Y1_1774868988 a_147_525# a_200_252# a_241_1232# a_230_525#
X0 a_230_525# a_200_252# a_147_525# a_241_1232# sky130_fd_pr__nfet_01v8 ad=0.0588 pd=0.7 as=0.0588 ps=0.7 w=0.42 l=0.15
X1 a_230_525# a_200_252# a_147_525# a_241_1232# sky130_fd_pr__nfet_01v8 ad=0.0588 pd=0.7 as=0.0588 ps=0.7 w=0.42 l=0.15
X2 a_147_525# a_200_252# a_230_525# a_241_1232# sky130_fd_pr__nfet_01v8 ad=0.0588 pd=0.7 as=0.0588 ps=0.7 w=0.42 l=0.15
X3 a_147_525# a_200_252# a_230_525# a_241_1232# sky130_fd_pr__nfet_01v8 ad=0.1113 pd=1.37 as=0.0588 ps=0.7 w=0.42 l=0.15
X4 a_230_525# a_200_252# a_147_525# a_241_1232# sky130_fd_pr__nfet_01v8 ad=0.0588 pd=0.7 as=0.0588 ps=0.7 w=0.42 l=0.15
X5 a_230_525# a_200_252# a_147_525# a_241_1232# sky130_fd_pr__nfet_01v8 ad=0.0588 pd=0.7 as=0.1113 ps=1.37 w=0.42 l=0.15
X6 a_147_525# a_200_252# a_230_525# a_241_1232# sky130_fd_pr__nfet_01v8 ad=0.0588 pd=0.7 as=0.0588 ps=0.7 w=0.42 l=0.15
X7 a_147_525# a_200_252# a_230_525# a_241_1232# sky130_fd_pr__nfet_01v8 ad=0.0588 pd=0.7 as=0.0588 ps=0.7 w=0.42 l=0.15
C0 a_147_525# a_230_525# 2.74987f
C1 a_147_525# a_200_252# 0.400523f
C2 a_230_525# a_200_252# 0.40492f
C3 a_230_525# a_241_1232# 0.348649f
C4 a_147_525# a_241_1232# 0.66087f
C5 a_200_252# a_241_1232# 2.27974f
.ends

.subckt SCM_NMOS_79747830_X2_Y1_1774868990 a_402_525# a_147_525# a_200_252#
X0 a_402_525# a_200_252# a_147_525# a_147_525# sky130_fd_pr__nfet_01v8 ad=0.0588 pd=0.7 as=0.0588 ps=0.7 w=0.42 l=0.15
X1 a_200_252# a_200_252# a_147_525# a_147_525# sky130_fd_pr__nfet_01v8 ad=0.0588 pd=0.7 as=0.0588 ps=0.7 w=0.42 l=0.15
X2 a_147_525# a_200_252# a_402_525# a_147_525# sky130_fd_pr__nfet_01v8 ad=0.0588 pd=0.7 as=0.0588 ps=0.7 w=0.42 l=0.15
X3 a_147_525# a_200_252# a_200_252# a_147_525# sky130_fd_pr__nfet_01v8 ad=0.1113 pd=1.37 as=0.0588 ps=0.7 w=0.42 l=0.15
X4 a_402_525# a_200_252# a_147_525# a_147_525# sky130_fd_pr__nfet_01v8 ad=0.0588 pd=0.7 as=0.0588 ps=0.7 w=0.42 l=0.15
X5 a_200_252# a_200_252# a_147_525# a_147_525# sky130_fd_pr__nfet_01v8 ad=0.0588 pd=0.7 as=0.1113 ps=1.37 w=0.42 l=0.15
X6 a_147_525# a_200_252# a_200_252# a_147_525# sky130_fd_pr__nfet_01v8 ad=0.0588 pd=0.7 as=0.0588 ps=0.7 w=0.42 l=0.15
X7 a_147_525# a_200_252# a_402_525# a_147_525# sky130_fd_pr__nfet_01v8 ad=0.0588 pd=0.7 as=0.0588 ps=0.7 w=0.42 l=0.15
C0 a_402_525# a_200_252# 0.429242f
C1 a_402_525# a_147_525# 1.50416f
C2 a_200_252# a_147_525# 4.90349f
.ends

.subckt FIVE_TRANSISTOR_OTA_0 IB VOUT VIP VIN VSS VDD
XPMOS_S_21674997_X6_Y1_1774868989_0 m1_774_1400# VDD VOUT VSS PMOS_S_21674997_X6_Y1_1774868989
XDCL_PMOS_S_80097108_X6_Y1_1774868987_0 m1_774_1400# VDD VSS DCL_PMOS_S_80097108_X6_Y1_1774868987
XNMOS_4T_66219913_X4_Y1_1774868988_0 m1_860_1316# VIN VSS VOUT NMOS_4T_66219913_X4_Y1_1774868988
XNMOS_4T_66219913_X4_Y1_1774868988_1 m1_860_1316# VIP VSS m1_774_1400# NMOS_4T_66219913_X4_Y1_1774868988
XSCM_NMOS_79747830_X2_Y1_1774868990_0 m1_860_1316# VSS IB SCM_NMOS_79747830_X2_Y1_1774868990
R0 m1_774_1400.n6 m1_774_1400.n4 716.029
R1 m1_774_1400.n31 m1_774_1400.n30 716.029
R2 m1_774_1400.n30 m1_774_1400.n29 715.644
R3 m1_774_1400.n3 m1_774_1400.n28 715.644
R4 m1_774_1400.n2 m1_774_1400.n7 715.644
R5 m1_774_1400.n6 m1_774_1400.n5 715.644
R6 m1_774_1400.n12 m1_774_1400.t22 568.582
R7 m1_774_1400.n12 m1_774_1400.t4 568.582
R8 m1_774_1400.n13 m1_774_1400.t12 568.582
R9 m1_774_1400.n13 m1_774_1400.t16 568.582
R10 m1_774_1400.n15 m1_774_1400.t18 568.582
R11 m1_774_1400.n15 m1_774_1400.t0 568.582
R12 m1_774_1400.n11 m1_774_1400.t6 568.582
R13 m1_774_1400.n11 m1_774_1400.t14 568.582
R14 m1_774_1400.n9 m1_774_1400.t20 568.582
R15 m1_774_1400.n9 m1_774_1400.t2 568.582
R16 m1_774_1400.n8 m1_774_1400.t8 568.582
R17 m1_774_1400.n8 m1_774_1400.t10 568.582
R18 m1_774_1400.n25 m1_774_1400.t30 568.582
R19 m1_774_1400.n25 m1_774_1400.t31 568.582
R20 m1_774_1400.n23 m1_774_1400.t34 568.582
R21 m1_774_1400.n23 m1_774_1400.t25 568.582
R22 m1_774_1400.n21 m1_774_1400.t28 568.582
R23 m1_774_1400.n21 m1_774_1400.t32 568.582
R24 m1_774_1400.n19 m1_774_1400.t35 568.582
R25 m1_774_1400.n19 m1_774_1400.t26 568.582
R26 m1_774_1400.n17 m1_774_1400.t27 568.582
R27 m1_774_1400.n17 m1_774_1400.t29 568.582
R28 m1_774_1400.n16 m1_774_1400.t33 568.582
R29 m1_774_1400.n16 m1_774_1400.t24 568.582
R30 m1_774_1400.n14 m1_774_1400.n12 161.685
R31 m1_774_1400.n10 m1_774_1400.n8 161.685
R32 m1_774_1400.n18 m1_774_1400.n16 161.685
R33 m1_774_1400.n14 m1_774_1400.n13 161.3
R34 m1_774_1400.n1 m1_774_1400.n15 161.3
R35 m1_774_1400.n0 m1_774_1400.n11 161.3
R36 m1_774_1400.n10 m1_774_1400.n9 161.3
R37 m1_774_1400.n26 m1_774_1400.n25 161.3
R38 m1_774_1400.n24 m1_774_1400.n23 161.3
R39 m1_774_1400.n22 m1_774_1400.n21 161.3
R40 m1_774_1400.n20 m1_774_1400.n19 161.3
R41 m1_774_1400.n18 m1_774_1400.n17 161.3
R42 m1_774_1400.n29 m1_774_1400.t17 65.6672
R43 m1_774_1400.n29 m1_774_1400.t13 65.6672
R44 m1_774_1400.n28 m1_774_1400.t1 65.6672
R45 m1_774_1400.n28 m1_774_1400.t19 65.6672
R46 m1_774_1400.n7 m1_774_1400.t15 65.6672
R47 m1_774_1400.n7 m1_774_1400.t7 65.6672
R48 m1_774_1400.n5 m1_774_1400.t3 65.6672
R49 m1_774_1400.n5 m1_774_1400.t21 65.6672
R50 m1_774_1400.n4 m1_774_1400.t11 65.6672
R51 m1_774_1400.n4 m1_774_1400.t9 65.6672
R52 m1_774_1400.n31 m1_774_1400.t5 65.6672
R53 m1_774_1400.t23 m1_774_1400.n31 65.6672
R54 m1_774_1400.n27 m1_774_1400.n26 46.7161
R55 m1_774_1400.n3 m1_774_1400.n27 6.188
R56 m1_774_1400.n27 m1_774_1400.n1 4.688
R57 m1_774_1400.n0 m1_774_1400.n10 0.384429
R58 m1_774_1400.n1 m1_774_1400.n14 0.384429
R59 m1_774_1400.n20 m1_774_1400.n18 0.384429
R60 m1_774_1400.n22 m1_774_1400.n20 0.384429
R61 m1_774_1400.n24 m1_774_1400.n22 0.384429
R62 m1_774_1400.n26 m1_774_1400.n24 0.384429
R63 m1_774_1400.n2 m1_774_1400.n6 0.384429
R64 m1_774_1400.n30 m1_774_1400.n3 0.384429
R65 m1_774_1400.n3 m1_774_1400.n2 0.384429
R66 m1_774_1400.n1 m1_774_1400.n0 0.384429
R67 VIN.n3 VIN.t6 568.582
R68 VIN.n3 VIN.t5 568.582
R69 VIN.n4 VIN.t2 568.582
R70 VIN.n4 VIN.t0 568.582
R71 VIN.n1 VIN.t7 568.582
R72 VIN.n1 VIN.t4 568.582
R73 VIN.n0 VIN.t3 568.582
R74 VIN.n0 VIN.t1 568.582
R75 VIN.n5 VIN.n3 161.685
R76 VIN.n2 VIN.n0 161.685
R77 VIN.n5 VIN.n4 161.3
R78 VIN.n2 VIN.n1 161.3
R79 VIN VIN.n2 0.192464
R80 VIN VIN.n5 0.192464
R81 VSS.n17 VSS.n0 2381.51
R82 VSS.n3 VSS.n0 1699.45
R83 VSS.n6 VSS.n5 1179.68
R84 VSS.n7 VSS.n6 1179.3
R85 VSS.n10 VSS.n1 1179.3
R86 VSS.n15 VSS.n14 1179.3
R87 VSS.n4 VSS.n2 232.148
R88 VSS.n9 VSS.n8 232.148
R89 VSS.n12 VSS.n11 232.148
R90 VSS VSS.n0 139.706
R91 VSS.n5 VSS.n3 116.075
R92 VSS.n5 VSS.n4 116.075
R93 VSS.n7 VSS.n2 116.075
R94 VSS.n8 VSS.n7 116.075
R95 VSS.n10 VSS.n9 116.075
R96 VSS.n11 VSS.n10 116.075
R97 VSS.n14 VSS.n12 116.075
R98 VSS.n14 VSS.n13 116.075
R99 VSS.n16 VSS.n15 11.8772
R100 VSS.n16 VSS 3.973
R101 VSS VSS.n17 3.58615
R102 VSS.n6 VSS.n1 0.384429
R103 VSS.n15 VSS.n1 0.384429
R104 VSS.n17 VSS.n16 0.216113
R105 VIP.n14 VIP.t3 535.02
R106 VIP.n12 VIP.t1 535.02
R107 VIP.n19 VIP.t7 535.02
R108 VIP.n17 VIP.t4 535.02
R109 VIP.n8 VIP.t2 535.02
R110 VIP.n6 VIP.t0 535.02
R111 VIP.n3 VIP.t6 535.02
R112 VIP.n1 VIP.t5 535.02
R113 VIP.n21 VIP.n15 161.685
R114 VIP.n10 VIP.n4 161.685
R115 VIP.n21 VIP.n20 161.3
R116 VIP.n10 VIP.n9 161.3
R117 VIP.n14 VIP.n13 28.9205
R118 VIP.n12 VIP.n11 28.9205
R119 VIP.n19 VIP.n18 28.9205
R120 VIP.n17 VIP.n16 28.9205
R121 VIP.n8 VIP.n7 28.9205
R122 VIP.n6 VIP.n5 28.9205
R123 VIP.n3 VIP.n2 28.9205
R124 VIP.n1 VIP.n0 28.9205
R125 VIP.n15 VIP.n12 24.9931
R126 VIP.n15 VIP.n14 24.9931
R127 VIP.n20 VIP.n17 24.9931
R128 VIP.n20 VIP.n19 24.9931
R129 VIP.n9 VIP.n6 24.9931
R130 VIP.n9 VIP.n8 24.9931
R131 VIP.n4 VIP.n1 24.9931
R132 VIP.n4 VIP.n3 24.9931
R133 VIP VIP.n10 0.192464
R134 VIP VIP.n21 0.192464
R135 IB.n7 IB.t0 568.582
R136 IB.n7 IB.t2 568.582
R137 IB.n6 IB.t9 568.582
R138 IB.n6 IB.t8 568.582
R139 IB.n4 IB.t11 568.582
R140 IB.n4 IB.t10 568.582
R141 IB.n3 IB.t4 568.582
R142 IB.n3 IB.t6 568.582
R143 IB.n2 IB.n0 316.413
R144 IB.n2 IB.n1 316.029
R145 IB.n8 IB.n7 161.685
R146 IB.n5 IB.n3 161.685
R147 IB.n8 IB.n6 161.3
R148 IB.n5 IB.n4 161.3
R149 IB.n1 IB.t1 40.0005
R150 IB.n1 IB.t3 40.0005
R151 IB.n0 IB.t5 40.0005
R152 IB.n0 IB.t7 40.0005
R153 IB IB.n2 5.438
R154 IB IB.n8 5.438
R155 IB.n8 IB.n5 0.384429
C0 VOUT m1_860_1316# 0.098304f
C1 VDD m1_860_1316# 0.418944f
C2 VDD VIP 0.177688f
C3 IB VIN 0.041045f
C4 VOUT IB 0.03176f
C5 IB VDD 0.22082f
C6 IB m1_860_1316# 0.248922f
C7 VOUT VIN 0.001268f
C8 VIN VDD 0.072535f
C9 VOUT VDD 0.248461f
C10 IB VIP 0.045111f
C11 m1_774_1400.n0 VSS 0.281396f
C12 m1_774_1400.n1 VSS 0.36513f
C13 m1_774_1400.n2 VSS 0.642628f
C14 m1_774_1400.n3 VSS 1.60444f
C15 m1_774_1400.t5 VSS 0.019766f
C16 m1_774_1400.t11 VSS 0.019766f
C17 m1_774_1400.t9 VSS 0.019766f
C18 m1_774_1400.n4 VSS 0.111992f
C19 m1_774_1400.t3 VSS 0.019766f
C20 m1_774_1400.t21 VSS 0.019766f
C21 m1_774_1400.n5 VSS 0.111652f
C22 m1_774_1400.n6 VSS 1.31692f
C23 m1_774_1400.t15 VSS 0.019766f
C24 m1_774_1400.t7 VSS 0.019766f
C25 m1_774_1400.n7 VSS 0.111652f
C26 m1_774_1400.t10 VSS -0.025427f
C27 m1_774_1400.t8 VSS -0.025427f
C28 m1_774_1400.n8 VSS 0.266417f
C29 m1_774_1400.t2 VSS -0.025427f
C30 m1_774_1400.t20 VSS -0.025427f
C31 m1_774_1400.n9 VSS 0.265769f
C32 m1_774_1400.n10 VSS 0.594146f
C33 m1_774_1400.t14 VSS -0.025427f
C34 m1_774_1400.t6 VSS -0.025427f
C35 m1_774_1400.n11 VSS 0.265769f
C36 m1_774_1400.t4 VSS -0.025427f
C37 m1_774_1400.t22 VSS -0.025427f
C38 m1_774_1400.n12 VSS 0.266417f
C39 m1_774_1400.t16 VSS -0.025427f
C40 m1_774_1400.t12 VSS -0.025427f
C41 m1_774_1400.n13 VSS 0.265769f
C42 m1_774_1400.n14 VSS 0.594146f
C43 m1_774_1400.t0 VSS -0.025427f
C44 m1_774_1400.t18 VSS -0.025427f
C45 m1_774_1400.n15 VSS 0.265769f
C46 m1_774_1400.t24 VSS -0.025427f
C47 m1_774_1400.t33 VSS -0.025427f
C48 m1_774_1400.n16 VSS 0.266417f
C49 m1_774_1400.t29 VSS -0.025427f
C50 m1_774_1400.t27 VSS -0.025427f
C51 m1_774_1400.n17 VSS 0.265769f
C52 m1_774_1400.n18 VSS 0.594146f
C53 m1_774_1400.t26 VSS -0.025427f
C54 m1_774_1400.t35 VSS -0.025427f
C55 m1_774_1400.n19 VSS 0.265769f
C56 m1_774_1400.n20 VSS 0.32187f
C57 m1_774_1400.t32 VSS -0.025427f
C58 m1_774_1400.t28 VSS -0.025427f
C59 m1_774_1400.n21 VSS 0.265769f
C60 m1_774_1400.n22 VSS 0.32187f
C61 m1_774_1400.t25 VSS -0.025427f
C62 m1_774_1400.t34 VSS -0.025427f
C63 m1_774_1400.n23 VSS 0.265769f
C64 m1_774_1400.n24 VSS 0.32187f
C65 m1_774_1400.t31 VSS -0.025427f
C66 m1_774_1400.t30 VSS -0.025427f
C67 m1_774_1400.n25 VSS 0.265769f
C68 m1_774_1400.n26 VSS 0.718137f
C69 m1_774_1400.n27 VSS 3.41768f
C70 m1_774_1400.t1 VSS 0.019766f
C71 m1_774_1400.t19 VSS 0.019766f
C72 m1_774_1400.n28 VSS 0.111652f
C73 m1_774_1400.t17 VSS 0.019766f
C74 m1_774_1400.t13 VSS 0.019766f
C75 m1_774_1400.n29 VSS 0.111652f
C76 m1_774_1400.n30 VSS 1.31692f
C77 m1_774_1400.n31 VSS 0.111992f
C78 m1_774_1400.t23 VSS 0.019766f
C79 IB VSS 4.592187f
C80 m1_860_1316# VSS 3.533634f
C81 VIP VSS 2.343972f
C82 VOUT VSS 8.351528f
C83 VIN VSS 2.420343f
C84 VDD VSS 35.436787f
.ends
