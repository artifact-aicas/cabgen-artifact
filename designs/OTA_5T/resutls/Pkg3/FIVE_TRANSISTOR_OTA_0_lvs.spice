* NGSPICE file created from FIVE_TRANSISTOR_OTA_0.ext - technology: sky130A

.subckt PMOS_S_21674997_X6_Y1_1774868989 a_200_252# w_0_0# a_230_525#
X0 w_0_0# a_200_252# a_230_525# w_0_0# sky130_fd_pr__pfet_01v8 ad=0.1113 pd=1.37 as=0.0588 ps=0.7 w=0.42 l=0.15 M=12
.ends

.subckt DCL_PMOS_S_80097108_X6_Y1_1774868987 a_200_252# w_0_0#
X0 w_0_0# a_200_252# a_200_252# w_0_0# sky130_fd_pr__pfet_01v8 ad=0.1113 pd=1.37 as=0.0588 ps=0.7 w=0.42 l=0.15 M=12
.ends

.subckt NMOS_4T_66219913_X4_Y1_1774868988 a_147_525# a_200_252# a_241_1232# a_230_525#
X0 a_230_525# a_200_252# a_147_525# a_241_1232# sky130_fd_pr__nfet_01v8 ad=0.0588 pd=0.7 as=0.0588 ps=0.7 w=0.42 l=0.15 M=8
.ends

.subckt SCM_NMOS_79747830_X2_Y1_1774868990 a_402_525# a_147_525# a_200_252#
X0 a_402_525# a_200_252# a_147_525# a_147_525# sky130_fd_pr__nfet_01v8 ad=0.0588 pd=0.7 as=0.0588 ps=0.7 w=0.42 l=0.15 M=4
X1 a_200_252# a_200_252# a_147_525# a_147_525# sky130_fd_pr__nfet_01v8 ad=0.0588 pd=0.7 as=0.0588 ps=0.7 w=0.42 l=0.15 M=4
.ends

.subckt FIVE_TRANSISTOR_OTA_0 IB VOUT VIP VIN VSS VDD
XPMOS_S_21674997_X6_Y1_1774868989_0 m1_774_1400# VDD VOUT PMOS_S_21674997_X6_Y1_1774868989
XDCL_PMOS_S_80097108_X6_Y1_1774868987_0 m1_774_1400# VDD DCL_PMOS_S_80097108_X6_Y1_1774868987
XNMOS_4T_66219913_X4_Y1_1774868988_0 m1_860_1316# VIN VSS VOUT NMOS_4T_66219913_X4_Y1_1774868988
XNMOS_4T_66219913_X4_Y1_1774868988_1 m1_860_1316# VIP VSS m1_774_1400# NMOS_4T_66219913_X4_Y1_1774868988
XSCM_NMOS_79747830_X2_Y1_1774868990_0 m1_860_1316# VSS IB SCM_NMOS_79747830_X2_Y1_1774868990
.ends
