* NGSPICE file created from FIVE_TRANSISTOR_OTA_0.ext - technology: sky130A

.subckt DCL_PMOS_S_8161858_X1_Y1_1774869053 a_200_252# w_0_0#
X0 a_200_252# a_200_252# w_0_0# w_0_0# sky130_fd_pr__pfet_01v8 ad=0.0882 pd=0.91 as=0.16695 ps=1.79 w=0.63 l=0.15 M=2
.ends

.subckt SCM_NMOS_1433580_X8_Y1_1774869056 a_147_504# a_200_252# a_402_504#
X0 a_147_504# a_200_252# a_402_504# a_147_504# sky130_fd_pr__nfet_01v8 ad=0.0882 pd=0.91 as=0.0882 ps=0.91 w=0.63 l=0.15 M=16
X1 a_200_252# a_200_252# a_147_504# a_147_504# sky130_fd_pr__nfet_01v8 ad=0.0882 pd=0.91 as=0.16695 ps=1.79 w=0.63 l=0.15 M=16
.ends

.subckt PMOS_S_96204883_X1_Y1_1774869055 a_200_252# w_0_0# a_230_504#
X0 a_230_504# a_200_252# w_0_0# w_0_0# sky130_fd_pr__pfet_01v8 ad=0.0882 pd=0.91 as=0.16695 ps=1.79 w=0.63 l=0.15 M=2
.ends

.subckt NMOS_4T_7455775_X4_Y2_1774869054 a_147_504# a_200_252# a_230_504# a_241_2408#
X0 a_230_504# a_200_252# a_147_504# a_241_2408# sky130_fd_pr__nfet_01v8 ad=0.0882 pd=0.91 as=0.16695 ps=1.79 w=0.63 l=0.15 M=16
.ends

.subckt FIVE_TRANSISTOR_OTA_0 IB VOUT VIP VIN VSS VDD
XDCL_PMOS_S_8161858_X1_Y1_1774869053_0 m2_574_1727# VDD DCL_PMOS_S_8161858_X1_Y1_1774869053
XSCM_NMOS_1433580_X8_Y1_1774869056_0 VSS IB m1_398_2828# SCM_NMOS_1433580_X8_Y1_1774869056
XPMOS_S_96204883_X1_Y1_1774869055_0 m2_574_1727# VDD VOUT PMOS_S_96204883_X1_Y1_1774869055
XNMOS_4T_7455775_X4_Y2_1774869054_0 m1_398_2828# VIN VOUT VSS NMOS_4T_7455775_X4_Y2_1774869054
XNMOS_4T_7455775_X4_Y2_1774869054_1 m1_398_2828# VIP m2_574_1727# VSS NMOS_4T_7455775_X4_Y2_1774869054
.ends
