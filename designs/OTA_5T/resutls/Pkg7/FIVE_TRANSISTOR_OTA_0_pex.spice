* NGSPICE file created from FIVE_TRANSISTOR_OTA_0.ext - technology: sky130A

.subckt DCL_PMOS_S_8161858_X1_Y1_1774869053 a_200_252# w_0_0# VSUBS
X0 a_200_252# a_200_252# w_0_0# w_0_0# sky130_fd_pr__pfet_01v8 ad=0.0882 pd=0.91 as=0.16695 ps=1.79 w=0.63 l=0.15
X1 w_0_0# a_200_252# a_200_252# w_0_0# sky130_fd_pr__pfet_01v8 ad=0.16695 pd=1.79 as=0.0882 ps=0.91 w=0.63 l=0.15
C0 a_200_252# w_0_0# 2.037f
C1 a_200_252# VSUBS 0.426498f
C2 w_0_0# VSUBS 2.90175f
.ends

.subckt SCM_NMOS_1433580_X8_Y1_1774869056 a_147_504# a_200_252# a_402_504#
X0 a_147_504# a_200_252# a_402_504# a_147_504# sky130_fd_pr__nfet_01v8 ad=0.0882 pd=0.91 as=0.0882 ps=0.91 w=0.63 l=0.15
X1 a_200_252# a_200_252# a_147_504# a_147_504# sky130_fd_pr__nfet_01v8 ad=0.0882 pd=0.91 as=0.16695 ps=1.79 w=0.63 l=0.15
X2 a_402_504# a_200_252# a_147_504# a_147_504# sky130_fd_pr__nfet_01v8 ad=0.0882 pd=0.91 as=0.0882 ps=0.91 w=0.63 l=0.15
X3 a_147_504# a_200_252# a_200_252# a_147_504# sky130_fd_pr__nfet_01v8 ad=0.0882 pd=0.91 as=0.0882 ps=0.91 w=0.63 l=0.15
X4 a_200_252# a_200_252# a_147_504# a_147_504# sky130_fd_pr__nfet_01v8 ad=0.0882 pd=0.91 as=0.0882 ps=0.91 w=0.63 l=0.15
X5 a_147_504# a_200_252# a_402_504# a_147_504# sky130_fd_pr__nfet_01v8 ad=0.0882 pd=0.91 as=0.0882 ps=0.91 w=0.63 l=0.15
X6 a_402_504# a_200_252# a_147_504# a_147_504# sky130_fd_pr__nfet_01v8 ad=0.0882 pd=0.91 as=0.0882 ps=0.91 w=0.63 l=0.15
X7 a_147_504# a_200_252# a_402_504# a_147_504# sky130_fd_pr__nfet_01v8 ad=0.0882 pd=0.91 as=0.0882 ps=0.91 w=0.63 l=0.15
X8 a_402_504# a_200_252# a_147_504# a_147_504# sky130_fd_pr__nfet_01v8 ad=0.0882 pd=0.91 as=0.0882 ps=0.91 w=0.63 l=0.15
X9 a_200_252# a_200_252# a_147_504# a_147_504# sky130_fd_pr__nfet_01v8 ad=0.0882 pd=0.91 as=0.0882 ps=0.91 w=0.63 l=0.15
X10 a_147_504# a_200_252# a_200_252# a_147_504# sky130_fd_pr__nfet_01v8 ad=0.0882 pd=0.91 as=0.0882 ps=0.91 w=0.63 l=0.15
X11 a_147_504# a_200_252# a_402_504# a_147_504# sky130_fd_pr__nfet_01v8 ad=0.0882 pd=0.91 as=0.0882 ps=0.91 w=0.63 l=0.15
X12 a_402_504# a_200_252# a_147_504# a_147_504# sky130_fd_pr__nfet_01v8 ad=0.0882 pd=0.91 as=0.0882 ps=0.91 w=0.63 l=0.15
X13 a_147_504# a_200_252# a_200_252# a_147_504# sky130_fd_pr__nfet_01v8 ad=0.0882 pd=0.91 as=0.0882 ps=0.91 w=0.63 l=0.15
X14 a_200_252# a_200_252# a_147_504# a_147_504# sky130_fd_pr__nfet_01v8 ad=0.0882 pd=0.91 as=0.0882 ps=0.91 w=0.63 l=0.15
X15 a_200_252# a_200_252# a_147_504# a_147_504# sky130_fd_pr__nfet_01v8 ad=0.0882 pd=0.91 as=0.0882 ps=0.91 w=0.63 l=0.15
X16 a_147_504# a_200_252# a_402_504# a_147_504# sky130_fd_pr__nfet_01v8 ad=0.0882 pd=0.91 as=0.0882 ps=0.91 w=0.63 l=0.15
X17 a_200_252# a_200_252# a_147_504# a_147_504# sky130_fd_pr__nfet_01v8 ad=0.0882 pd=0.91 as=0.0882 ps=0.91 w=0.63 l=0.15
X18 a_402_504# a_200_252# a_147_504# a_147_504# sky130_fd_pr__nfet_01v8 ad=0.0882 pd=0.91 as=0.0882 ps=0.91 w=0.63 l=0.15
X19 a_147_504# a_200_252# a_402_504# a_147_504# sky130_fd_pr__nfet_01v8 ad=0.0882 pd=0.91 as=0.0882 ps=0.91 w=0.63 l=0.15
X20 a_200_252# a_200_252# a_147_504# a_147_504# sky130_fd_pr__nfet_01v8 ad=0.0882 pd=0.91 as=0.0882 ps=0.91 w=0.63 l=0.15
X21 a_147_504# a_200_252# a_402_504# a_147_504# sky130_fd_pr__nfet_01v8 ad=0.0882 pd=0.91 as=0.0882 ps=0.91 w=0.63 l=0.15
X22 a_147_504# a_200_252# a_200_252# a_147_504# sky130_fd_pr__nfet_01v8 ad=0.0882 pd=0.91 as=0.0882 ps=0.91 w=0.63 l=0.15
X23 a_402_504# a_200_252# a_147_504# a_147_504# sky130_fd_pr__nfet_01v8 ad=0.0882 pd=0.91 as=0.0882 ps=0.91 w=0.63 l=0.15
X24 a_200_252# a_200_252# a_147_504# a_147_504# sky130_fd_pr__nfet_01v8 ad=0.0882 pd=0.91 as=0.0882 ps=0.91 w=0.63 l=0.15
X25 a_147_504# a_200_252# a_200_252# a_147_504# sky130_fd_pr__nfet_01v8 ad=0.16695 pd=1.79 as=0.0882 ps=0.91 w=0.63 l=0.15
X26 a_402_504# a_200_252# a_147_504# a_147_504# sky130_fd_pr__nfet_01v8 ad=0.0882 pd=0.91 as=0.0882 ps=0.91 w=0.63 l=0.15
X27 a_147_504# a_200_252# a_200_252# a_147_504# sky130_fd_pr__nfet_01v8 ad=0.0882 pd=0.91 as=0.0882 ps=0.91 w=0.63 l=0.15
X28 a_402_504# a_200_252# a_147_504# a_147_504# sky130_fd_pr__nfet_01v8 ad=0.0882 pd=0.91 as=0.0882 ps=0.91 w=0.63 l=0.15
X29 a_147_504# a_200_252# a_200_252# a_147_504# sky130_fd_pr__nfet_01v8 ad=0.0882 pd=0.91 as=0.0882 ps=0.91 w=0.63 l=0.15
X30 a_147_504# a_200_252# a_402_504# a_147_504# sky130_fd_pr__nfet_01v8 ad=0.0882 pd=0.91 as=0.0882 ps=0.91 w=0.63 l=0.15
X31 a_147_504# a_200_252# a_200_252# a_147_504# sky130_fd_pr__nfet_01v8 ad=0.0882 pd=0.91 as=0.0882 ps=0.91 w=0.63 l=0.15
C0 a_402_504# a_200_252# 2.39282f
C1 a_402_504# a_147_504# 6.76688f
C2 a_200_252# a_147_504# 16.1915f
.ends

.subckt PMOS_S_96204883_X1_Y1_1774869055 a_200_252# w_0_0# a_230_504# VSUBS
X0 a_230_504# a_200_252# w_0_0# w_0_0# sky130_fd_pr__pfet_01v8 ad=0.0882 pd=0.91 as=0.16695 ps=1.79 w=0.63 l=0.15
X1 w_0_0# a_200_252# a_230_504# w_0_0# sky130_fd_pr__pfet_01v8 ad=0.16695 pd=1.79 as=0.0882 ps=0.91 w=0.63 l=0.15
C0 w_0_0# a_230_504# 0.780198f
C1 a_200_252# a_230_504# 0.102797f
C2 a_200_252# w_0_0# 0.737877f
C3 a_230_504# VSUBS 0.07188f
C4 a_200_252# VSUBS 0.199823f
C5 w_0_0# VSUBS 2.98399f
.ends

.subckt NMOS_4T_7455775_X4_Y2_1774869054 a_147_504# a_200_252# a_230_504# a_241_2408#
X0 a_230_504# a_200_252# a_147_504# a_241_2408# sky130_fd_pr__nfet_01v8 ad=0.0882 pd=0.91 as=0.16695 ps=1.79 w=0.63 l=0.15
X1 a_147_504# a_200_252# a_230_504# a_241_2408# sky130_fd_pr__nfet_01v8 ad=0.0882 pd=0.91 as=0.0882 ps=0.91 w=0.63 l=0.15
X2 a_147_504# a_200_252# a_230_504# a_241_2408# sky130_fd_pr__nfet_01v8 ad=0.0882 pd=0.91 as=0.0882 ps=0.91 w=0.63 l=0.15
X3 a_230_504# a_200_252# a_147_504# a_241_2408# sky130_fd_pr__nfet_01v8 ad=0.0882 pd=0.91 as=0.0882 ps=0.91 w=0.63 l=0.15
X4 a_230_504# a_200_252# a_147_504# a_241_2408# sky130_fd_pr__nfet_01v8 ad=0.0882 pd=0.91 as=0.0882 ps=0.91 w=0.63 l=0.15
X5 a_147_504# a_200_252# a_230_504# a_241_2408# sky130_fd_pr__nfet_01v8 ad=0.0882 pd=0.91 as=0.0882 ps=0.91 w=0.63 l=0.15
X6 a_147_504# a_200_252# a_230_504# a_241_2408# sky130_fd_pr__nfet_01v8 ad=0.16695 pd=1.79 as=0.0882 ps=0.91 w=0.63 l=0.15
X7 a_230_504# a_200_252# a_147_504# a_241_2408# sky130_fd_pr__nfet_01v8 ad=0.0882 pd=0.91 as=0.0882 ps=0.91 w=0.63 l=0.15
X8 a_147_504# a_200_252# a_230_504# a_241_2408# sky130_fd_pr__nfet_01v8 ad=0.0882 pd=0.91 as=0.0882 ps=0.91 w=0.63 l=0.15
X9 a_230_504# a_200_252# a_147_504# a_241_2408# sky130_fd_pr__nfet_01v8 ad=0.0882 pd=0.91 as=0.16695 ps=1.79 w=0.63 l=0.15
X10 a_230_504# a_200_252# a_147_504# a_241_2408# sky130_fd_pr__nfet_01v8 ad=0.0882 pd=0.91 as=0.0882 ps=0.91 w=0.63 l=0.15
X11 a_147_504# a_200_252# a_230_504# a_241_2408# sky130_fd_pr__nfet_01v8 ad=0.16695 pd=1.79 as=0.0882 ps=0.91 w=0.63 l=0.15
X12 a_147_504# a_200_252# a_230_504# a_241_2408# sky130_fd_pr__nfet_01v8 ad=0.0882 pd=0.91 as=0.0882 ps=0.91 w=0.63 l=0.15
X13 a_230_504# a_200_252# a_147_504# a_241_2408# sky130_fd_pr__nfet_01v8 ad=0.0882 pd=0.91 as=0.0882 ps=0.91 w=0.63 l=0.15
X14 a_147_504# a_200_252# a_230_504# a_241_2408# sky130_fd_pr__nfet_01v8 ad=0.0882 pd=0.91 as=0.0882 ps=0.91 w=0.63 l=0.15
X15 a_230_504# a_200_252# a_147_504# a_241_2408# sky130_fd_pr__nfet_01v8 ad=0.0882 pd=0.91 as=0.0882 ps=0.91 w=0.63 l=0.15
C0 a_200_252# a_230_504# 1.30081f
C1 a_147_504# a_230_504# 5.92733f
C2 a_147_504# a_200_252# 1.27761f
C3 a_230_504# a_241_2408# 0.805078f
C4 a_147_504# a_241_2408# 1.45141f
C5 a_200_252# a_241_2408# 4.46551f
.ends

.subckt FIVE_TRANSISTOR_OTA_0 IB VOUT VIP VIN VSS VDD
XDCL_PMOS_S_8161858_X1_Y1_1774869053_0 m2_574_1727# VDD VSS DCL_PMOS_S_8161858_X1_Y1_1774869053
XSCM_NMOS_1433580_X8_Y1_1774869056_0 VSS IB m1_398_2828# SCM_NMOS_1433580_X8_Y1_1774869056
XPMOS_S_96204883_X1_Y1_1774869055_0 m2_574_1727# VDD VOUT VSS PMOS_S_96204883_X1_Y1_1774869055
XNMOS_4T_7455775_X4_Y2_1774869054_0 m1_398_2828# VIN VOUT VSS NMOS_4T_7455775_X4_Y2_1774869054
XNMOS_4T_7455775_X4_Y2_1774869054_1 m1_398_2828# VIP m2_574_1727# VSS NMOS_4T_7455775_X4_Y2_1774869054
R0 m2_574_1727.t1 m2_574_1727.n2 716.457
R1 m2_574_1727.n0 m2_574_1727.t2 568.582
R2 m2_574_1727.n0 m2_574_1727.t0 568.582
R3 m2_574_1727.n1 m2_574_1727.t5 568.582
R4 m2_574_1727.n1 m2_574_1727.t4 568.582
R5 m2_574_1727.n2 m2_574_1727.n1 207.056
R6 m2_574_1727.n2 m2_574_1727.n0 165.988
R7 m2_574_1727.t3 m2_574_1727.t1 43.7783
R8 IB.n16 IB.t30 568.582
R9 IB.n16 IB.t28 568.582
R10 IB.n17 IB.t39 568.582
R11 IB.n17 IB.t43 568.582
R12 IB.n19 IB.t46 568.582
R13 IB.n19 IB.t34 568.582
R14 IB.n21 IB.t16 568.582
R15 IB.n21 IB.t10 568.582
R16 IB.n23 IB.t8 568.582
R17 IB.n23 IB.t0 568.582
R18 IB.n25 IB.t37 568.582
R19 IB.n25 IB.t40 568.582
R20 IB.n27 IB.t45 568.582
R21 IB.n27 IB.t32 568.582
R22 IB.n15 IB.t24 568.582
R23 IB.n15 IB.t22 568.582
R24 IB.n13 IB.t14 568.582
R25 IB.n13 IB.t4 568.582
R26 IB.n11 IB.t33 568.582
R27 IB.n11 IB.t38 568.582
R28 IB.n9 IB.t41 568.582
R29 IB.n9 IB.t42 568.582
R30 IB.n7 IB.t12 568.582
R31 IB.n7 IB.t2 568.582
R32 IB.n5 IB.t26 568.582
R33 IB.n5 IB.t20 568.582
R34 IB.n3 IB.t44 568.582
R35 IB.n3 IB.t47 568.582
R36 IB.n1 IB.t35 568.582
R37 IB.n1 IB.t36 568.582
R38 IB.n0 IB.t18 568.582
R39 IB.n0 IB.t6 568.582
R40 IB.n40 IB.n38 311.421
R41 IB.n32 IB.n30 311.421
R42 IB.n40 IB.n39 310.269
R43 IB.n42 IB.n41 310.269
R44 IB.n43 IB.n37 310.269
R45 IB.n36 IB.n35 310.269
R46 IB.n34 IB.n33 310.269
R47 IB.n32 IB.n31 310.269
R48 IB.n18 IB.n16 161.685
R49 IB.n2 IB.n0 161.685
R50 IB.n18 IB.n17 161.3
R51 IB.n20 IB.n19 161.3
R52 IB.n22 IB.n21 161.3
R53 IB.n24 IB.n23 161.3
R54 IB.n26 IB.n25 161.3
R55 IB.n28 IB.n27 161.3
R56 IB.n29 IB.n15 161.3
R57 IB.n14 IB.n13 161.3
R58 IB.n12 IB.n11 161.3
R59 IB.n10 IB.n9 161.3
R60 IB.n8 IB.n7 161.3
R61 IB.n6 IB.n5 161.3
R62 IB.n4 IB.n3 161.3
R63 IB.n2 IB.n1 161.3
R64 IB.n38 IB.t29 26.6672
R65 IB.n38 IB.t31 26.6672
R66 IB.n39 IB.t11 26.6672
R67 IB.n39 IB.t17 26.6672
R68 IB.n41 IB.t1 26.6672
R69 IB.n41 IB.t9 26.6672
R70 IB.n37 IB.t23 26.6672
R71 IB.n37 IB.t25 26.6672
R72 IB.n35 IB.t5 26.6672
R73 IB.n35 IB.t15 26.6672
R74 IB.n33 IB.t3 26.6672
R75 IB.n33 IB.t13 26.6672
R76 IB.n31 IB.t21 26.6672
R77 IB.n31 IB.t27 26.6672
R78 IB.n30 IB.t7 26.6672
R79 IB.n30 IB.t19 26.6672
R80 IB IB.n29 5.438
R81 IB IB.n43 5.438
R82 IB.n36 IB.n34 1.15229
R83 IB.n43 IB.n42 1.15229
R84 IB.n4 IB.n2 0.384429
R85 IB.n6 IB.n4 0.384429
R86 IB.n8 IB.n6 0.384429
R87 IB.n10 IB.n8 0.384429
R88 IB.n12 IB.n10 0.384429
R89 IB.n14 IB.n12 0.384429
R90 IB.n29 IB.n14 0.384429
R91 IB.n29 IB.n28 0.384429
R92 IB.n28 IB.n26 0.384429
R93 IB.n26 IB.n24 0.384429
R94 IB.n24 IB.n22 0.384429
R95 IB.n22 IB.n20 0.384429
R96 IB.n20 IB.n18 0.384429
R97 IB.n34 IB.n32 0.384429
R98 IB.n43 IB.n36 0.384429
R99 IB.n42 IB.n40 0.384429
R100 VSS.n22 VSS.n21 7676.72
R101 VSS.n28 VSS.n27 1179.68
R102 VSS.n15 VSS.n14 1179.68
R103 VSS.n27 VSS.n26 1179.3
R104 VSS.n10 VSS.n4 1179.3
R105 VSS.n7 VSS.n0 1179.3
R106 VSS.n16 VSS.n15 1179.3
R107 VSS.n20 VSS.n1 1179.3
R108 VSS.n48 VSS.n47 1179.3
R109 VSS.n23 VSS.n22 403.315
R110 VSS.n13 VSS.n11 394.99
R111 VSS.n18 VSS.n17 394.99
R112 VSS.n19 VSS.n2 394.99
R113 VSS.n46 VSS.n45 394.99
R114 VSS.n45 VSS.n44 394.99
R115 VSS.n44 VSS.n43 394.99
R116 VSS.n43 VSS.n42 394.99
R117 VSS.n42 VSS.n41 394.99
R118 VSS.n41 VSS.n40 394.99
R119 VSS.n40 VSS.n39 394.99
R120 VSS.n39 VSS.n38 394.99
R121 VSS.n38 VSS.n37 394.99
R122 VSS.n37 VSS.n36 394.99
R123 VSS.n36 VSS.n35 394.99
R124 VSS.n35 VSS.n34 394.99
R125 VSS.n34 VSS.n33 394.99
R126 VSS.n33 VSS.n32 394.99
R127 VSS.n32 VSS.n31 274.094
R128 VSS.n14 VSS.n12 197.495
R129 VSS.n14 VSS.n13 197.495
R130 VSS.n16 VSS.n11 197.495
R131 VSS.n17 VSS.n16 197.495
R132 VSS.n20 VSS.n19 197.495
R133 VSS.n47 VSS.n2 197.495
R134 VSS.n47 VSS.n46 197.495
R135 VSS.n31 VSS.n30 153.198
R136 VSS.n30 VSS.n29 153.198
R137 VSS.n5 VSS.n3 153.198
R138 VSS.n25 VSS.n24 153.198
R139 VSS.n9 VSS.n8 153.198
R140 VSS.n21 VSS.n20 114.823
R141 VSS.n21 VSS.n18 82.6727
R142 VSS.n29 VSS.n28 76.5997
R143 VSS.n28 VSS.n3 76.5997
R144 VSS.n26 VSS.n5 76.5997
R145 VSS.n26 VSS.n25 76.5997
R146 VSS.n10 VSS.n9 76.5997
R147 VSS.n8 VSS.n7 76.5997
R148 VSS.n7 VSS.n6 76.5997
R149 VSS.n23 VSS.n10 48.0977
R150 VSS.n24 VSS.n23 28.5025
R151 VSS.n49 VSS.n48 15.5865
R152 VSS.n49 VSS.n0 12.1341
R153 VSS.n22 VSS 10.8033
R154 VSS VSS.n49 0.427085
R155 VSS.n27 VSS.n4 0.384429
R156 VSS.n4 VSS.n0 0.384429
R157 VSS.n15 VSS.n1 0.384429
R158 VSS.n48 VSS.n1 0.384429
R159 VIN.n3 VIN.t1 568.582
R160 VIN.n3 VIN.t0 568.582
R161 VIN.n4 VIN.t5 568.582
R162 VIN.n4 VIN.t3 568.582
R163 VIN.n1 VIN.t2 568.582
R164 VIN.n1 VIN.t13 568.582
R165 VIN.n0 VIN.t6 568.582
R166 VIN.n0 VIN.t4 568.582
R167 VIN.n10 VIN.t12 568.582
R168 VIN.n10 VIN.t9 568.582
R169 VIN.n11 VIN.t8 568.582
R170 VIN.n11 VIN.t15 568.582
R171 VIN.n8 VIN.t14 568.582
R172 VIN.n8 VIN.t10 568.582
R173 VIN.n7 VIN.t11 568.582
R174 VIN.n7 VIN.t7 568.582
R175 VIN.n5 VIN.n3 161.685
R176 VIN.n2 VIN.n0 161.685
R177 VIN.n12 VIN.n10 161.685
R178 VIN.n9 VIN.n7 161.685
R179 VIN.n5 VIN.n4 161.3
R180 VIN.n2 VIN.n1 161.3
R181 VIN.n12 VIN.n11 161.3
R182 VIN.n9 VIN.n8 161.3
R183 VIN VIN.n6 5.813
R184 VIN VIN.n13 5.813
R185 VIN.n6 VIN.n2 0.192464
R186 VIN.n6 VIN.n5 0.192464
R187 VIN.n13 VIN.n9 0.192464
R188 VIN.n13 VIN.n12 0.192464
R189 VIP.n14 VIP.t6 573.581
R190 VIP.n12 VIP.t4 573.581
R191 VIP.n19 VIP.t2 573.581
R192 VIP.n17 VIP.t13 573.581
R193 VIP.n8 VIP.t5 573.581
R194 VIP.n6 VIP.t3 573.581
R195 VIP.n3 VIP.t1 573.581
R196 VIP.n1 VIP.t0 573.581
R197 VIP.n37 VIP.t11 573.581
R198 VIP.n35 VIP.t7 573.581
R199 VIP.n42 VIP.t14 573.581
R200 VIP.n40 VIP.t10 573.581
R201 VIP.n31 VIP.t8 573.581
R202 VIP.n29 VIP.t15 573.581
R203 VIP.n26 VIP.t12 573.581
R204 VIP.n24 VIP.t9 573.581
R205 VIP.n21 VIP.n15 161.685
R206 VIP.n10 VIP.n4 161.685
R207 VIP.n44 VIP.n38 161.685
R208 VIP.n33 VIP.n27 161.685
R209 VIP.n21 VIP.n20 161.3
R210 VIP.n10 VIP.n9 161.3
R211 VIP.n44 VIP.n43 161.3
R212 VIP.n33 VIP.n32 161.3
R213 VIP.n14 VIP.n13 33.7405
R214 VIP.n12 VIP.n11 33.7405
R215 VIP.n19 VIP.n18 33.7405
R216 VIP.n17 VIP.n16 33.7405
R217 VIP.n8 VIP.n7 33.7405
R218 VIP.n6 VIP.n5 33.7405
R219 VIP.n3 VIP.n2 33.7405
R220 VIP.n1 VIP.n0 33.7405
R221 VIP.n37 VIP.n36 33.7405
R222 VIP.n35 VIP.n34 33.7405
R223 VIP.n42 VIP.n41 33.7405
R224 VIP.n40 VIP.n39 33.7405
R225 VIP.n31 VIP.n30 33.7405
R226 VIP.n29 VIP.n28 33.7405
R227 VIP.n26 VIP.n25 33.7405
R228 VIP.n24 VIP.n23 33.7405
R229 VIP.n15 VIP.n12 24.9931
R230 VIP.n15 VIP.n14 24.9931
R231 VIP.n20 VIP.n17 24.9931
R232 VIP.n20 VIP.n19 24.9931
R233 VIP.n9 VIP.n6 24.9931
R234 VIP.n9 VIP.n8 24.9931
R235 VIP.n4 VIP.n1 24.9931
R236 VIP.n4 VIP.n3 24.9931
R237 VIP.n38 VIP.n35 24.9931
R238 VIP.n38 VIP.n37 24.9931
R239 VIP.n43 VIP.n40 24.9931
R240 VIP.n43 VIP.n42 24.9931
R241 VIP.n32 VIP.n29 24.9931
R242 VIP.n32 VIP.n31 24.9931
R243 VIP.n27 VIP.n24 24.9931
R244 VIP.n27 VIP.n26 24.9931
R245 VIP VIP.n22 5.813
R246 VIP VIP.n45 5.813
R247 VIP.n22 VIP.n10 0.192464
R248 VIP.n22 VIP.n21 0.192464
R249 VIP.n45 VIP.n33 0.192464
R250 VIP.n45 VIP.n44 0.192464
C0 VDD VIP 0.173224f
C1 VOUT VIP 4.36e-19
C2 VIN m1_398_2828# -0.021657f
C3 VIN IB 0.008946f
C4 VIN VDD 0.350064f
C5 m1_398_2828# IB 0.165153f
C6 VDD m1_398_2828# 0.538235f
C7 VDD IB 0.702224f
C8 VIN VOUT 0.054885f
C9 m1_398_2828# VOUT 0.227551f
C10 VIN VIP 0.017202f
C11 VOUT IB 0.232622f
C12 VDD VOUT 0.369547f
C13 m1_398_2828# VIP 0.001099f
C14 IB VIP 0.008946f
C15 IB.t6 VSS -6.07e-19
C16 IB.t18 VSS -6.07e-19
C17 IB.n0 VSS 0.038045f
C18 IB.t36 VSS -6.07e-19
C19 IB.t35 VSS -6.07e-19
C20 IB.n1 VSS 0.037952f
C21 IB.n2 VSS 0.084845f
C22 IB.t47 VSS -6.07e-19
C23 IB.t44 VSS -6.07e-19
C24 IB.n3 VSS 0.037952f
C25 IB.n4 VSS 0.045964f
C26 IB.t20 VSS -6.07e-19
C27 IB.t26 VSS -6.07e-19
C28 IB.n5 VSS 0.037952f
C29 IB.n6 VSS 0.045964f
C30 IB.t2 VSS -6.07e-19
C31 IB.t12 VSS -6.07e-19
C32 IB.n7 VSS 0.037952f
C33 IB.n8 VSS 0.045964f
C34 IB.t42 VSS -6.07e-19
C35 IB.t41 VSS -6.07e-19
C36 IB.n9 VSS 0.037952f
C37 IB.n10 VSS 0.045964f
C38 IB.t38 VSS -6.07e-19
C39 IB.t33 VSS -6.07e-19
C40 IB.n11 VSS 0.037952f
C41 IB.n12 VSS 0.045964f
C42 IB.t4 VSS -6.07e-19
C43 IB.t14 VSS -6.07e-19
C44 IB.n13 VSS 0.037952f
C45 IB.n14 VSS 0.045964f
C46 IB.t22 VSS -6.07e-19
C47 IB.t24 VSS -6.07e-19
C48 IB.n15 VSS 0.037952f
C49 IB.t28 VSS -6.07e-19
C50 IB.t30 VSS -6.07e-19
C51 IB.n16 VSS 0.038045f
C52 IB.t43 VSS -6.07e-19
C53 IB.t39 VSS -6.07e-19
C54 IB.n17 VSS 0.037952f
C55 IB.n18 VSS 0.084845f
C56 IB.t34 VSS -6.07e-19
C57 IB.t46 VSS -6.07e-19
C58 IB.n19 VSS 0.037952f
C59 IB.n20 VSS 0.045964f
C60 IB.t10 VSS -6.07e-19
C61 IB.t16 VSS -6.07e-19
C62 IB.n21 VSS 0.037952f
C63 IB.n22 VSS 0.045964f
C64 IB.t0 VSS -6.07e-19
C65 IB.t8 VSS -6.07e-19
C66 IB.n23 VSS 0.037952f
C67 IB.n24 VSS 0.045964f
C68 IB.t40 VSS -6.07e-19
C69 IB.t37 VSS -6.07e-19
C70 IB.n25 VSS 0.037952f
C71 IB.n26 VSS 0.045964f
C72 IB.t32 VSS -6.07e-19
C73 IB.t45 VSS -6.07e-19
C74 IB.n27 VSS 0.037952f
C75 IB.n28 VSS 0.045964f
C76 IB.n29 VSS 0.051572f
C77 IB.t7 VSS 0.004234f
C78 IB.t19 VSS 0.004234f
C79 IB.n30 VSS 0.032126f
C80 IB.t21 VSS 0.004234f
C81 IB.t27 VSS 0.004234f
C82 IB.n31 VSS 0.031754f
C83 IB.n32 VSS 0.207999f
C84 IB.t3 VSS 0.004234f
C85 IB.t13 VSS 0.004234f
C86 IB.n33 VSS 0.031754f
C87 IB.n34 VSS 0.10768f
C88 IB.t5 VSS 0.004234f
C89 IB.t15 VSS 0.004234f
C90 IB.n35 VSS 0.031754f
C91 IB.n36 VSS 0.10768f
C92 IB.t23 VSS 0.004234f
C93 IB.t25 VSS 0.004234f
C94 IB.n37 VSS 0.031754f
C95 IB.t29 VSS 0.004234f
C96 IB.t31 VSS 0.004234f
C97 IB.n38 VSS 0.032126f
C98 IB.t11 VSS 0.004234f
C99 IB.t17 VSS 0.004234f
C100 IB.n39 VSS 0.031754f
C101 IB.n40 VSS 0.207999f
C102 IB.t1 VSS 0.004234f
C103 IB.t9 VSS 0.004234f
C104 IB.n41 VSS 0.031754f
C105 IB.n42 VSS 0.10768f
C106 IB.n43 VSS 0.113288f
C107 m2_574_1727.t2 VSS -0.003428f
C108 m2_574_1727.t0 VSS -0.003428f
C109 m2_574_1727.n0 VSS 0.223254f
C110 m2_574_1727.t5 VSS -0.003428f
C111 m2_574_1727.t4 VSS -0.003428f
C112 m2_574_1727.n1 VSS 0.30015f
C113 m2_574_1727.n2 VSS 8.7261f
C114 m2_574_1727.t1 VSS 0.140289f
C115 m2_574_1727.t3 VSS 0.023919f
C116 m1_398_2828# VSS 9.7286f
C117 VIP VSS 4.509909f
C118 VOUT VSS 6.860069f
C119 VIN VSS 4.275186f
C120 VDD VSS 12.287892f
C121 IB VSS 16.18842f
.ends
