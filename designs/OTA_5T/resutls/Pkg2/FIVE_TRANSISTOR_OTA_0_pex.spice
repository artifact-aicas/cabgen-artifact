* NGSPICE file created from FIVE_TRANSISTOR_OTA_0.ext - technology: sky130A

.subckt DCL_PMOS_S_33011438_X8_Y1_1774868971 a_200_252# w_0_0# VSUBS
X0 a_200_252# a_200_252# w_0_0# w_0_0# sky130_fd_pr__pfet_01v8 ad=0.0882 pd=0.91 as=0.0882 ps=0.91 w=0.63 l=0.15
X1 w_0_0# a_200_252# a_200_252# w_0_0# sky130_fd_pr__pfet_01v8 ad=0.16695 pd=1.79 as=0.0882 ps=0.91 w=0.63 l=0.15
X2 a_200_252# a_200_252# w_0_0# w_0_0# sky130_fd_pr__pfet_01v8 ad=0.0882 pd=0.91 as=0.0882 ps=0.91 w=0.63 l=0.15
X3 a_200_252# a_200_252# w_0_0# w_0_0# sky130_fd_pr__pfet_01v8 ad=0.0882 pd=0.91 as=0.0882 ps=0.91 w=0.63 l=0.15
X4 a_200_252# a_200_252# w_0_0# w_0_0# sky130_fd_pr__pfet_01v8 ad=0.0882 pd=0.91 as=0.0882 ps=0.91 w=0.63 l=0.15
X5 w_0_0# a_200_252# a_200_252# w_0_0# sky130_fd_pr__pfet_01v8 ad=0.0882 pd=0.91 as=0.0882 ps=0.91 w=0.63 l=0.15
X6 w_0_0# a_200_252# a_200_252# w_0_0# sky130_fd_pr__pfet_01v8 ad=0.0882 pd=0.91 as=0.0882 ps=0.91 w=0.63 l=0.15
X7 w_0_0# a_200_252# a_200_252# w_0_0# sky130_fd_pr__pfet_01v8 ad=0.0882 pd=0.91 as=0.0882 ps=0.91 w=0.63 l=0.15
X8 a_200_252# a_200_252# w_0_0# w_0_0# sky130_fd_pr__pfet_01v8 ad=0.0882 pd=0.91 as=0.0882 ps=0.91 w=0.63 l=0.15
X9 a_200_252# a_200_252# w_0_0# w_0_0# sky130_fd_pr__pfet_01v8 ad=0.0882 pd=0.91 as=0.0882 ps=0.91 w=0.63 l=0.15
X10 a_200_252# a_200_252# w_0_0# w_0_0# sky130_fd_pr__pfet_01v8 ad=0.0882 pd=0.91 as=0.0882 ps=0.91 w=0.63 l=0.15
X11 w_0_0# a_200_252# a_200_252# w_0_0# sky130_fd_pr__pfet_01v8 ad=0.0882 pd=0.91 as=0.0882 ps=0.91 w=0.63 l=0.15
X12 w_0_0# a_200_252# a_200_252# w_0_0# sky130_fd_pr__pfet_01v8 ad=0.0882 pd=0.91 as=0.0882 ps=0.91 w=0.63 l=0.15
X13 a_200_252# a_200_252# w_0_0# w_0_0# sky130_fd_pr__pfet_01v8 ad=0.0882 pd=0.91 as=0.16695 ps=1.79 w=0.63 l=0.15
X14 w_0_0# a_200_252# a_200_252# w_0_0# sky130_fd_pr__pfet_01v8 ad=0.0882 pd=0.91 as=0.0882 ps=0.91 w=0.63 l=0.15
X15 w_0_0# a_200_252# a_200_252# w_0_0# sky130_fd_pr__pfet_01v8 ad=0.0882 pd=0.91 as=0.0882 ps=0.91 w=0.63 l=0.15
C0 w_0_0# a_200_252# 11.087299f
C1 a_200_252# VSUBS 0.869222f
C2 w_0_0# VSUBS 8.15697f
.ends

.subckt NMOS_4T_45526871_X3_Y1_1774868972 a_147_504# a_200_252# a_230_504# a_241_1232#
X0 a_230_504# a_200_252# a_147_504# a_241_1232# sky130_fd_pr__nfet_01v8 ad=0.0882 pd=0.91 as=0.16695 ps=1.79 w=0.63 l=0.15
X1 a_147_504# a_200_252# a_230_504# a_241_1232# sky130_fd_pr__nfet_01v8 ad=0.0882 pd=0.91 as=0.0882 ps=0.91 w=0.63 l=0.15
X2 a_147_504# a_200_252# a_230_504# a_241_1232# sky130_fd_pr__nfet_01v8 ad=0.16695 pd=1.79 as=0.0882 ps=0.91 w=0.63 l=0.15
X3 a_230_504# a_200_252# a_147_504# a_241_1232# sky130_fd_pr__nfet_01v8 ad=0.0882 pd=0.91 as=0.0882 ps=0.91 w=0.63 l=0.15
X4 a_147_504# a_200_252# a_230_504# a_241_1232# sky130_fd_pr__nfet_01v8 ad=0.0882 pd=0.91 as=0.0882 ps=0.91 w=0.63 l=0.15
X5 a_230_504# a_200_252# a_147_504# a_241_1232# sky130_fd_pr__nfet_01v8 ad=0.0882 pd=0.91 as=0.0882 ps=0.91 w=0.63 l=0.15
C0 a_147_504# a_230_504# 2.04755f
C1 a_200_252# a_147_504# 0.288824f
C2 a_200_252# a_230_504# 0.294983f
C3 a_230_504# a_241_1232# 0.254279f
C4 a_147_504# a_241_1232# 0.586694f
C5 a_200_252# a_241_1232# 1.69736f
.ends

.subckt SCM_NMOS_53863688_X7_Y1_1774868974 a_147_504# a_200_252# a_402_504#
X0 a_147_504# a_200_252# a_200_252# a_147_504# sky130_fd_pr__nfet_01v8 ad=0.0882 pd=0.91 as=0.0882 ps=0.91 w=0.63 l=0.15
X1 a_200_252# a_200_252# a_147_504# a_147_504# sky130_fd_pr__nfet_01v8 ad=0.0882 pd=0.91 as=0.16695 ps=1.79 w=0.63 l=0.15
X2 a_402_504# a_200_252# a_147_504# a_147_504# sky130_fd_pr__nfet_01v8 ad=0.0882 pd=0.91 as=0.0882 ps=0.91 w=0.63 l=0.15
X3 a_147_504# a_200_252# a_200_252# a_147_504# sky130_fd_pr__nfet_01v8 ad=0.0882 pd=0.91 as=0.0882 ps=0.91 w=0.63 l=0.15
X4 a_200_252# a_200_252# a_147_504# a_147_504# sky130_fd_pr__nfet_01v8 ad=0.0882 pd=0.91 as=0.0882 ps=0.91 w=0.63 l=0.15
X5 a_147_504# a_200_252# a_200_252# a_147_504# sky130_fd_pr__nfet_01v8 ad=0.0882 pd=0.91 as=0.0882 ps=0.91 w=0.63 l=0.15
X6 a_402_504# a_200_252# a_147_504# a_147_504# sky130_fd_pr__nfet_01v8 ad=0.0882 pd=0.91 as=0.0882 ps=0.91 w=0.63 l=0.15
X7 a_402_504# a_200_252# a_147_504# a_147_504# sky130_fd_pr__nfet_01v8 ad=0.0882 pd=0.91 as=0.0882 ps=0.91 w=0.63 l=0.15
X8 a_147_504# a_200_252# a_402_504# a_147_504# sky130_fd_pr__nfet_01v8 ad=0.0882 pd=0.91 as=0.0882 ps=0.91 w=0.63 l=0.15
X9 a_147_504# a_200_252# a_402_504# a_147_504# sky130_fd_pr__nfet_01v8 ad=0.0882 pd=0.91 as=0.0882 ps=0.91 w=0.63 l=0.15
X10 a_402_504# a_200_252# a_147_504# a_147_504# sky130_fd_pr__nfet_01v8 ad=0.0882 pd=0.91 as=0.0882 ps=0.91 w=0.63 l=0.15
X11 a_147_504# a_200_252# a_200_252# a_147_504# sky130_fd_pr__nfet_01v8 ad=0.0882 pd=0.91 as=0.0882 ps=0.91 w=0.63 l=0.15
X12 a_402_504# a_200_252# a_147_504# a_147_504# sky130_fd_pr__nfet_01v8 ad=0.0882 pd=0.91 as=0.0882 ps=0.91 w=0.63 l=0.15
X13 a_147_504# a_200_252# a_402_504# a_147_504# sky130_fd_pr__nfet_01v8 ad=0.0882 pd=0.91 as=0.0882 ps=0.91 w=0.63 l=0.15
X14 a_200_252# a_200_252# a_147_504# a_147_504# sky130_fd_pr__nfet_01v8 ad=0.0882 pd=0.91 as=0.0882 ps=0.91 w=0.63 l=0.15
X15 a_200_252# a_200_252# a_147_504# a_147_504# sky130_fd_pr__nfet_01v8 ad=0.0882 pd=0.91 as=0.0882 ps=0.91 w=0.63 l=0.15
X16 a_147_504# a_200_252# a_200_252# a_147_504# sky130_fd_pr__nfet_01v8 ad=0.0882 pd=0.91 as=0.0882 ps=0.91 w=0.63 l=0.15
X17 a_402_504# a_200_252# a_147_504# a_147_504# sky130_fd_pr__nfet_01v8 ad=0.0882 pd=0.91 as=0.0882 ps=0.91 w=0.63 l=0.15
X18 a_147_504# a_200_252# a_402_504# a_147_504# sky130_fd_pr__nfet_01v8 ad=0.0882 pd=0.91 as=0.0882 ps=0.91 w=0.63 l=0.15
X19 a_147_504# a_200_252# a_402_504# a_147_504# sky130_fd_pr__nfet_01v8 ad=0.0882 pd=0.91 as=0.0882 ps=0.91 w=0.63 l=0.15
X20 a_402_504# a_200_252# a_147_504# a_147_504# sky130_fd_pr__nfet_01v8 ad=0.0882 pd=0.91 as=0.0882 ps=0.91 w=0.63 l=0.15
X21 a_200_252# a_200_252# a_147_504# a_147_504# sky130_fd_pr__nfet_01v8 ad=0.0882 pd=0.91 as=0.0882 ps=0.91 w=0.63 l=0.15
X22 a_200_252# a_200_252# a_147_504# a_147_504# sky130_fd_pr__nfet_01v8 ad=0.0882 pd=0.91 as=0.0882 ps=0.91 w=0.63 l=0.15
X23 a_147_504# a_200_252# a_200_252# a_147_504# sky130_fd_pr__nfet_01v8 ad=0.0882 pd=0.91 as=0.0882 ps=0.91 w=0.63 l=0.15
X24 a_200_252# a_200_252# a_147_504# a_147_504# sky130_fd_pr__nfet_01v8 ad=0.0882 pd=0.91 as=0.0882 ps=0.91 w=0.63 l=0.15
X25 a_147_504# a_200_252# a_402_504# a_147_504# sky130_fd_pr__nfet_01v8 ad=0.0882 pd=0.91 as=0.0882 ps=0.91 w=0.63 l=0.15
X26 a_147_504# a_200_252# a_402_504# a_147_504# sky130_fd_pr__nfet_01v8 ad=0.16695 pd=1.79 as=0.0882 ps=0.91 w=0.63 l=0.15
X27 a_147_504# a_200_252# a_200_252# a_147_504# sky130_fd_pr__nfet_01v8 ad=0.0882 pd=0.91 as=0.0882 ps=0.91 w=0.63 l=0.15
C0 a_200_252# a_402_504# 2.06863f
C1 a_402_504# a_147_504# 6.06012f
C2 a_200_252# a_147_504# 14.158799f
.ends

.subckt PMOS_S_10792591_X8_Y1_1774868973 a_200_252# w_0_0# a_230_504# VSUBS
X0 a_230_504# a_200_252# w_0_0# w_0_0# sky130_fd_pr__pfet_01v8 ad=0.0882 pd=0.91 as=0.0882 ps=0.91 w=0.63 l=0.15
X1 w_0_0# a_200_252# a_230_504# w_0_0# sky130_fd_pr__pfet_01v8 ad=0.16695 pd=1.79 as=0.0882 ps=0.91 w=0.63 l=0.15
X2 a_230_504# a_200_252# w_0_0# w_0_0# sky130_fd_pr__pfet_01v8 ad=0.0882 pd=0.91 as=0.0882 ps=0.91 w=0.63 l=0.15
X3 a_230_504# a_200_252# w_0_0# w_0_0# sky130_fd_pr__pfet_01v8 ad=0.0882 pd=0.91 as=0.0882 ps=0.91 w=0.63 l=0.15
X4 a_230_504# a_200_252# w_0_0# w_0_0# sky130_fd_pr__pfet_01v8 ad=0.0882 pd=0.91 as=0.0882 ps=0.91 w=0.63 l=0.15
X5 w_0_0# a_200_252# a_230_504# w_0_0# sky130_fd_pr__pfet_01v8 ad=0.0882 pd=0.91 as=0.0882 ps=0.91 w=0.63 l=0.15
X6 w_0_0# a_200_252# a_230_504# w_0_0# sky130_fd_pr__pfet_01v8 ad=0.0882 pd=0.91 as=0.0882 ps=0.91 w=0.63 l=0.15
X7 w_0_0# a_200_252# a_230_504# w_0_0# sky130_fd_pr__pfet_01v8 ad=0.0882 pd=0.91 as=0.0882 ps=0.91 w=0.63 l=0.15
X8 a_230_504# a_200_252# w_0_0# w_0_0# sky130_fd_pr__pfet_01v8 ad=0.0882 pd=0.91 as=0.0882 ps=0.91 w=0.63 l=0.15
X9 a_230_504# a_200_252# w_0_0# w_0_0# sky130_fd_pr__pfet_01v8 ad=0.0882 pd=0.91 as=0.0882 ps=0.91 w=0.63 l=0.15
X10 a_230_504# a_200_252# w_0_0# w_0_0# sky130_fd_pr__pfet_01v8 ad=0.0882 pd=0.91 as=0.0882 ps=0.91 w=0.63 l=0.15
X11 w_0_0# a_200_252# a_230_504# w_0_0# sky130_fd_pr__pfet_01v8 ad=0.0882 pd=0.91 as=0.0882 ps=0.91 w=0.63 l=0.15
X12 w_0_0# a_200_252# a_230_504# w_0_0# sky130_fd_pr__pfet_01v8 ad=0.0882 pd=0.91 as=0.0882 ps=0.91 w=0.63 l=0.15
X13 a_230_504# a_200_252# w_0_0# w_0_0# sky130_fd_pr__pfet_01v8 ad=0.0882 pd=0.91 as=0.16695 ps=1.79 w=0.63 l=0.15
X14 w_0_0# a_200_252# a_230_504# w_0_0# sky130_fd_pr__pfet_01v8 ad=0.0882 pd=0.91 as=0.0882 ps=0.91 w=0.63 l=0.15
X15 w_0_0# a_200_252# a_230_504# w_0_0# sky130_fd_pr__pfet_01v8 ad=0.0882 pd=0.91 as=0.0882 ps=0.91 w=0.63 l=0.15
C0 a_200_252# a_230_504# 0.787303f
C1 w_0_0# a_200_252# 4.54832f
C2 w_0_0# a_230_504# 6.00827f
C3 a_230_504# VSUBS 0.326991f
C4 a_200_252# VSUBS 0.479845f
C5 w_0_0# VSUBS 8.131269f
.ends

.subckt FIVE_TRANSISTOR_OTA_0 IB VOUT VIP VIN VSS VDD
XDCL_PMOS_S_33011438_X8_Y1_1774868971_0 m1_1462_560# VDD VSS DCL_PMOS_S_33011438_X8_Y1_1774868971
XNMOS_4T_45526871_X3_Y1_1774868972_0 m1_1548_1652# VIN VOUT VSS NMOS_4T_45526871_X3_Y1_1774868972
XSCM_NMOS_53863688_X7_Y1_1774868974_0 VSS IB m1_1548_1652# SCM_NMOS_53863688_X7_Y1_1774868974
XNMOS_4T_45526871_X3_Y1_1774868972_1 m1_1548_1652# VIP m1_1462_560# VSS NMOS_4T_45526871_X3_Y1_1774868972
XPMOS_S_10792591_X8_Y1_1774868973_0 m1_1462_560# VDD VOUT VSS PMOS_S_10792591_X8_Y1_1774868973
R0 m1_1462_560.n75 m1_1462_560.n73 710.653
R1 m1_1462_560.n2 m1_1462_560.n0 710.653
R2 m1_1462_560.n75 m1_1462_560.n74 710.269
R3 m1_1462_560.n72 m1_1462_560.n71 710.269
R4 m1_1462_560.n6 m1_1462_560.n5 710.269
R5 m1_1462_560.n4 m1_1462_560.n3 710.269
R6 m1_1462_560.n2 m1_1462_560.n1 710.269
R7 m1_1462_560.n77 m1_1462_560.n76 710.269
R8 m1_1462_560.n25 m1_1462_560.t33 573.581
R9 m1_1462_560.n23 m1_1462_560.t34 573.581
R10 m1_1462_560.n30 m1_1462_560.t44 573.581
R11 m1_1462_560.n28 m1_1462_560.t41 573.581
R12 m1_1462_560.n36 m1_1462_560.t37 573.581
R13 m1_1462_560.n34 m1_1462_560.t32 573.581
R14 m1_1462_560.n42 m1_1462_560.t43 573.581
R15 m1_1462_560.n40 m1_1462_560.t40 573.581
R16 m1_1462_560.n48 m1_1462_560.t39 573.581
R17 m1_1462_560.n46 m1_1462_560.t36 573.581
R18 m1_1462_560.n54 m1_1462_560.t47 573.581
R19 m1_1462_560.n52 m1_1462_560.t42 573.581
R20 m1_1462_560.n60 m1_1462_560.t38 573.581
R21 m1_1462_560.n58 m1_1462_560.t35 573.581
R22 m1_1462_560.n66 m1_1462_560.t46 573.581
R23 m1_1462_560.n64 m1_1462_560.t45 573.581
R24 m1_1462_560.n14 m1_1462_560.t2 568.582
R25 m1_1462_560.n14 m1_1462_560.t4 568.582
R26 m1_1462_560.n15 m1_1462_560.t18 568.582
R27 m1_1462_560.n15 m1_1462_560.t24 568.582
R28 m1_1462_560.n17 m1_1462_560.t0 568.582
R29 m1_1462_560.n17 m1_1462_560.t10 568.582
R30 m1_1462_560.n19 m1_1462_560.t16 568.582
R31 m1_1462_560.n19 m1_1462_560.t22 568.582
R32 m1_1462_560.n12 m1_1462_560.t8 568.582
R33 m1_1462_560.n12 m1_1462_560.t14 568.582
R34 m1_1462_560.n10 m1_1462_560.t20 568.582
R35 m1_1462_560.n10 m1_1462_560.t30 568.582
R36 m1_1462_560.n8 m1_1462_560.t6 568.582
R37 m1_1462_560.n8 m1_1462_560.t12 568.582
R38 m1_1462_560.n7 m1_1462_560.t28 568.582
R39 m1_1462_560.n7 m1_1462_560.t26 568.582
R40 m1_1462_560.n32 m1_1462_560.n26 161.685
R41 m1_1462_560.n16 m1_1462_560.n14 161.685
R42 m1_1462_560.n9 m1_1462_560.n7 161.685
R43 m1_1462_560.n32 m1_1462_560.n31 161.3
R44 m1_1462_560.n38 m1_1462_560.n37 161.3
R45 m1_1462_560.n44 m1_1462_560.n43 161.3
R46 m1_1462_560.n50 m1_1462_560.n49 161.3
R47 m1_1462_560.n56 m1_1462_560.n55 161.3
R48 m1_1462_560.n62 m1_1462_560.n61 161.3
R49 m1_1462_560.n68 m1_1462_560.n67 161.3
R50 m1_1462_560.n16 m1_1462_560.n15 161.3
R51 m1_1462_560.n18 m1_1462_560.n17 161.3
R52 m1_1462_560.n20 m1_1462_560.n19 161.3
R53 m1_1462_560.n13 m1_1462_560.n12 161.3
R54 m1_1462_560.n11 m1_1462_560.n10 161.3
R55 m1_1462_560.n9 m1_1462_560.n8 161.3
R56 m1_1462_560.n73 m1_1462_560.t3 43.7783
R57 m1_1462_560.n73 m1_1462_560.t5 43.7783
R58 m1_1462_560.n74 m1_1462_560.t19 43.7783
R59 m1_1462_560.n74 m1_1462_560.t25 43.7783
R60 m1_1462_560.n71 m1_1462_560.t17 43.7783
R61 m1_1462_560.n71 m1_1462_560.t23 43.7783
R62 m1_1462_560.n5 m1_1462_560.t9 43.7783
R63 m1_1462_560.n5 m1_1462_560.t15 43.7783
R64 m1_1462_560.n3 m1_1462_560.t21 43.7783
R65 m1_1462_560.n3 m1_1462_560.t31 43.7783
R66 m1_1462_560.n1 m1_1462_560.t7 43.7783
R67 m1_1462_560.n1 m1_1462_560.t13 43.7783
R68 m1_1462_560.n0 m1_1462_560.t29 43.7783
R69 m1_1462_560.n0 m1_1462_560.t27 43.7783
R70 m1_1462_560.t1 m1_1462_560.n77 43.7783
R71 m1_1462_560.n77 m1_1462_560.t11 43.7783
R72 m1_1462_560.n25 m1_1462_560.n24 33.7405
R73 m1_1462_560.n23 m1_1462_560.n22 33.7405
R74 m1_1462_560.n30 m1_1462_560.n29 33.7405
R75 m1_1462_560.n28 m1_1462_560.n27 33.7405
R76 m1_1462_560.n36 m1_1462_560.n35 33.7405
R77 m1_1462_560.n34 m1_1462_560.n33 33.7405
R78 m1_1462_560.n42 m1_1462_560.n41 33.7405
R79 m1_1462_560.n40 m1_1462_560.n39 33.7405
R80 m1_1462_560.n48 m1_1462_560.n47 33.7405
R81 m1_1462_560.n46 m1_1462_560.n45 33.7405
R82 m1_1462_560.n54 m1_1462_560.n53 33.7405
R83 m1_1462_560.n52 m1_1462_560.n51 33.7405
R84 m1_1462_560.n60 m1_1462_560.n59 33.7405
R85 m1_1462_560.n58 m1_1462_560.n57 33.7405
R86 m1_1462_560.n66 m1_1462_560.n65 33.7405
R87 m1_1462_560.n64 m1_1462_560.n63 33.7405
R88 m1_1462_560.n26 m1_1462_560.n23 24.9931
R89 m1_1462_560.n26 m1_1462_560.n25 24.9931
R90 m1_1462_560.n31 m1_1462_560.n28 24.9931
R91 m1_1462_560.n31 m1_1462_560.n30 24.9931
R92 m1_1462_560.n37 m1_1462_560.n34 24.9931
R93 m1_1462_560.n37 m1_1462_560.n36 24.9931
R94 m1_1462_560.n43 m1_1462_560.n40 24.9931
R95 m1_1462_560.n43 m1_1462_560.n42 24.9931
R96 m1_1462_560.n49 m1_1462_560.n46 24.9931
R97 m1_1462_560.n49 m1_1462_560.n48 24.9931
R98 m1_1462_560.n55 m1_1462_560.n52 24.9931
R99 m1_1462_560.n55 m1_1462_560.n54 24.9931
R100 m1_1462_560.n61 m1_1462_560.n58 24.9931
R101 m1_1462_560.n61 m1_1462_560.n60 24.9931
R102 m1_1462_560.n67 m1_1462_560.n64 24.9931
R103 m1_1462_560.n67 m1_1462_560.n66 24.9931
R104 m1_1462_560.n69 m1_1462_560.n68 16.1835
R105 m1_1462_560.n70 m1_1462_560.n69 6.188
R106 m1_1462_560.n69 m1_1462_560.n21 4.688
R107 m1_1462_560.n68 m1_1462_560.n62 0.384429
R108 m1_1462_560.n62 m1_1462_560.n56 0.384429
R109 m1_1462_560.n56 m1_1462_560.n50 0.384429
R110 m1_1462_560.n50 m1_1462_560.n44 0.384429
R111 m1_1462_560.n44 m1_1462_560.n38 0.384429
R112 m1_1462_560.n38 m1_1462_560.n32 0.384429
R113 m1_1462_560.n11 m1_1462_560.n9 0.384429
R114 m1_1462_560.n13 m1_1462_560.n11 0.384429
R115 m1_1462_560.n20 m1_1462_560.n18 0.384429
R116 m1_1462_560.n18 m1_1462_560.n16 0.384429
R117 m1_1462_560.n4 m1_1462_560.n2 0.384429
R118 m1_1462_560.n6 m1_1462_560.n4 0.384429
R119 m1_1462_560.n76 m1_1462_560.n72 0.384429
R120 m1_1462_560.n76 m1_1462_560.n75 0.384429
R121 m1_1462_560.n21 m1_1462_560.n13 0.192464
R122 m1_1462_560.n21 m1_1462_560.n20 0.192464
R123 m1_1462_560.n70 m1_1462_560.n6 0.192464
R124 m1_1462_560.n72 m1_1462_560.n70 0.192464
R125 VDD.n2 VDD 458.159
R126 VDD.n8 VDD.n3 379.685
R127 VDD.n21 VDD.n17 379.685
R128 VDD.n8 VDD.n7 379.3
R129 VDD.n10 VDD.n9 379.3
R130 VDD.n13 VDD.n0 379.3
R131 VDD.n29 VDD.n16 379.3
R132 VDD.n28 VDD.n27 379.3
R133 VDD.n24 VDD.n17 379.3
R134 VDD.n5 VDD.n4 54.0349
R135 VDD.n6 VDD.n1 54.0349
R136 VDD.n12 VDD.n11 54.0349
R137 VDD.n15 VDD.n14 54.0349
R138 VDD.n19 VDD.n18 54.0349
R139 VDD.n26 VDD.n25 54.0349
R140 VDD.n23 VDD.n22 54.0349
R141 VDD.n3 VDD.n2 27.0177
R142 VDD.n4 VDD.n3 27.0177
R143 VDD.n7 VDD.n5 27.0177
R144 VDD.n7 VDD.n6 27.0177
R145 VDD.n10 VDD.n1 27.0177
R146 VDD.n11 VDD.n10 27.0177
R147 VDD.n13 VDD.n12 27.0177
R148 VDD.n14 VDD.n13 27.0177
R149 VDD.n16 VDD.n15 27.0177
R150 VDD.n18 VDD.n16 27.0177
R151 VDD.n27 VDD.n19 27.0177
R152 VDD.n27 VDD.n26 27.0177
R153 VDD.n25 VDD.n24 27.0177
R154 VDD.n24 VDD.n23 27.0177
R155 VDD.n22 VDD.n21 27.0177
R156 VDD.n21 VDD.n20 27.0177
R157 VDD.n30 VDD.n29 17.971
R158 VDD.n30 VDD 12.946
R159 VDD VDD.n30 3.93746
R160 VDD.n9 VDD.n8 0.384429
R161 VDD.n9 VDD.n0 0.384429
R162 VDD.n29 VDD.n0 0.384429
R163 VDD.n29 VDD.n28 0.384429
R164 VDD.n28 VDD.n17 0.384429
R165 VIN.n2 VIN.t0 568.582
R166 VIN.n2 VIN.t1 568.582
R167 VIN.n1 VIN.t3 568.582
R168 VIN.n1 VIN.t4 568.582
R169 VIN.n0 VIN.t5 568.582
R170 VIN.n0 VIN.t2 568.582
R171 VIN VIN.n2 161.685
R172 VIN VIN.n0 161.685
R173 VIN VIN.n1 161.3
R174 VSS.n24 VSS.n3 273863
R175 VSS.n19 VSS.n1 1179.68
R176 VSS.n10 VSS.n9 1179.68
R177 VSS.n20 VSS.n1 1179.3
R178 VSS.n26 VSS.n25 1179.3
R179 VSS.n8 VSS.n6 1179.3
R180 VSS.n14 VSS.n13 1179.3
R181 VSS.n15 VSS.n5 1179.3
R182 VSS.n17 VSS.n16 1179.3
R183 VSS.n18 VSS.n4 1179.3
R184 VSS.n22 VSS.n21 1179.3
R185 VSS.n23 VSS.n2 1179.3
R186 VSS.n10 VSS.n7 1179.3
R187 VSS.n12 VSS.n11 1179.3
R188 VSS.n6 VSS.n3 533.053
R189 VSS.n25 VSS.n24 457.618
R190 VSS.n17 VSS.n5 252.773
R191 VSS.n18 VSS.n17 252.773
R192 VSS.n9 VSS.n3 240.523
R193 VSS.n9 VSS.n8 126.386
R194 VSS.n8 VSS.n7 126.386
R195 VSS.n13 VSS.n7 126.386
R196 VSS.n13 VSS.n12 126.386
R197 VSS.n12 VSS.n5 126.386
R198 VSS.n19 VSS.n18 126.386
R199 VSS.n21 VSS.n19 126.386
R200 VSS.n21 VSS.n20 126.386
R201 VSS.n20 VSS.n2 126.386
R202 VSS.n25 VSS.n2 126.386
R203 VSS.n24 VSS.n23 114.915
R204 VSS.n11 VSS.n0 10.5248
R205 VSS.n27 VSS.n26 10.348
R206 VSS.n22 VSS 8.6255
R207 VSS VSS.n0 5.098
R208 VSS VSS.n27 3.91457
R209 VSS.n14 VSS.n6 0.384429
R210 VSS.n15 VSS.n14 0.384429
R211 VSS.n16 VSS.n15 0.384429
R212 VSS.n16 VSS.n4 0.384429
R213 VSS.n22 VSS.n4 0.384429
R214 VSS.n23 VSS.n22 0.384429
R215 VSS.n26 VSS.n1 0.384429
R216 VSS.n11 VSS.n10 0.384429
R217 VSS.n27 VSS.n0 0.0762875
R218 IB.n12 IB.t41 568.582
R219 IB.n12 IB.t39 568.582
R220 IB.n13 IB.t16 568.582
R221 IB.n13 IB.t20 568.582
R222 IB.n15 IB.t40 568.582
R223 IB.n15 IB.t36 568.582
R224 IB.n17 IB.t10 568.582
R225 IB.n17 IB.t12 568.582
R226 IB.n19 IB.t32 568.582
R227 IB.n19 IB.t28 568.582
R228 IB.n21 IB.t4 568.582
R229 IB.n21 IB.t14 568.582
R230 IB.n23 IB.t31 568.582
R231 IB.n23 IB.t30 568.582
R232 IB.n11 IB.t26 568.582
R233 IB.n11 IB.t6 568.582
R234 IB.n9 IB.t35 568.582
R235 IB.n9 IB.t29 568.582
R236 IB.n7 IB.t0 568.582
R237 IB.n7 IB.t8 568.582
R238 IB.n5 IB.t38 568.582
R239 IB.n5 IB.t34 568.582
R240 IB.n3 IB.t18 568.582
R241 IB.n3 IB.t2 568.582
R242 IB.n1 IB.t37 568.582
R243 IB.n1 IB.t33 568.582
R244 IB.n0 IB.t22 568.582
R245 IB.n0 IB.t24 568.582
R246 IB.n34 IB.n32 311.036
R247 IB.n28 IB.n26 311.036
R248 IB.n34 IB.n33 310.269
R249 IB.n36 IB.n35 310.269
R250 IB.n37 IB.n31 310.269
R251 IB.n30 IB.n29 310.269
R252 IB.n28 IB.n27 310.269
R253 IB.n14 IB.n12 161.685
R254 IB.n2 IB.n0 161.685
R255 IB.n14 IB.n13 161.3
R256 IB.n16 IB.n15 161.3
R257 IB.n18 IB.n17 161.3
R258 IB.n20 IB.n19 161.3
R259 IB.n22 IB.n21 161.3
R260 IB.n24 IB.n23 161.3
R261 IB.n25 IB.n11 161.3
R262 IB.n10 IB.n9 161.3
R263 IB.n8 IB.n7 161.3
R264 IB.n6 IB.n5 161.3
R265 IB.n4 IB.n3 161.3
R266 IB.n2 IB.n1 161.3
R267 IB.n32 IB.t21 26.6672
R268 IB.n32 IB.t17 26.6672
R269 IB.n33 IB.t13 26.6672
R270 IB.n33 IB.t11 26.6672
R271 IB.n35 IB.t15 26.6672
R272 IB.n35 IB.t5 26.6672
R273 IB.n31 IB.t7 26.6672
R274 IB.n31 IB.t27 26.6672
R275 IB.n29 IB.t9 26.6672
R276 IB.n29 IB.t1 26.6672
R277 IB.n27 IB.t3 26.6672
R278 IB.n27 IB.t19 26.6672
R279 IB.n26 IB.t25 26.6672
R280 IB.n26 IB.t23 26.6672
R281 IB IB.n25 5.438
R282 IB IB.n37 5.438
R283 IB.n30 IB.n28 0.768357
R284 IB.n37 IB.n30 0.768357
R285 IB.n37 IB.n36 0.768357
R286 IB.n36 IB.n34 0.768357
R287 IB.n4 IB.n2 0.384429
R288 IB.n6 IB.n4 0.384429
R289 IB.n8 IB.n6 0.384429
R290 IB.n10 IB.n8 0.384429
R291 IB.n25 IB.n10 0.384429
R292 IB.n25 IB.n24 0.384429
R293 IB.n24 IB.n22 0.384429
R294 IB.n22 IB.n20 0.384429
R295 IB.n20 IB.n18 0.384429
R296 IB.n18 IB.n16 0.384429
R297 IB.n16 IB.n14 0.384429
R298 VIP.n2 VIP.t2 568.582
R299 VIP.n2 VIP.t5 568.582
R300 VIP.n1 VIP.t4 568.582
R301 VIP.n1 VIP.t3 568.582
R302 VIP.n0 VIP.t1 568.582
R303 VIP.n0 VIP.t0 568.582
R304 VIP VIP.n2 161.685
R305 VIP VIP.n0 161.685
R306 VIP VIP.n1 161.3
C0 IB VIN 0.005253f
C1 VDD IB 0.489075f
C2 IB m1_1548_1652# 0.13851f
C3 VIN VOUT 0.001287f
C4 VDD VIN 0.023206f
C5 VIN m1_1548_1652# 0.025154f
C6 VIP IB 0.005253f
C7 VDD VOUT 0.075752f
C8 m1_1548_1652# VOUT 0.039718f
C9 VIP VIN 0.039365f
C10 VDD m1_1548_1652# 0.341495f
C11 VDD VIP 0.051303f
C12 VIP m1_1548_1652# 0.009503f
C13 IB.t24 VSS -5.9e-19
C14 IB.t22 VSS -5.9e-19
C15 IB.n0 VSS 0.036976f
C16 IB.t33 VSS -5.9e-19
C17 IB.t37 VSS -5.9e-19
C18 IB.n1 VSS 0.036886f
C19 IB.n2 VSS 0.082462f
C20 IB.t2 VSS -5.9e-19
C21 IB.t18 VSS -5.9e-19
C22 IB.n3 VSS 0.036886f
C23 IB.n4 VSS 0.044673f
C24 IB.t34 VSS -5.9e-19
C25 IB.t38 VSS -5.9e-19
C26 IB.n5 VSS 0.036886f
C27 IB.n6 VSS 0.044673f
C28 IB.t8 VSS -5.9e-19
C29 IB.t0 VSS -5.9e-19
C30 IB.n7 VSS 0.036886f
C31 IB.n8 VSS 0.044673f
C32 IB.t29 VSS -5.9e-19
C33 IB.t35 VSS -5.9e-19
C34 IB.n9 VSS 0.036886f
C35 IB.n10 VSS 0.044673f
C36 IB.t6 VSS -5.9e-19
C37 IB.t26 VSS -5.9e-19
C38 IB.n11 VSS 0.036886f
C39 IB.t39 VSS -5.9e-19
C40 IB.t41 VSS -5.9e-19
C41 IB.n12 VSS 0.036976f
C42 IB.t20 VSS -5.9e-19
C43 IB.t16 VSS -5.9e-19
C44 IB.n13 VSS 0.036886f
C45 IB.n14 VSS 0.082462f
C46 IB.t36 VSS -5.9e-19
C47 IB.t40 VSS -5.9e-19
C48 IB.n15 VSS 0.036886f
C49 IB.n16 VSS 0.044673f
C50 IB.t12 VSS -5.9e-19
C51 IB.t10 VSS -5.9e-19
C52 IB.n17 VSS 0.036886f
C53 IB.n18 VSS 0.044673f
C54 IB.t28 VSS -5.9e-19
C55 IB.t32 VSS -5.9e-19
C56 IB.n19 VSS 0.036886f
C57 IB.n20 VSS 0.044673f
C58 IB.t14 VSS -5.9e-19
C59 IB.t4 VSS -5.9e-19
C60 IB.n21 VSS 0.036886f
C61 IB.n22 VSS 0.044673f
C62 IB.t30 VSS -5.9e-19
C63 IB.t31 VSS -5.9e-19
C64 IB.n23 VSS 0.036886f
C65 IB.n24 VSS 0.044673f
C66 IB.n25 VSS 0.050123f
C67 IB.t25 VSS 0.004115f
C68 IB.t23 VSS 0.004115f
C69 IB.n26 VSS 0.031076f
C70 IB.t3 VSS 0.004115f
C71 IB.t19 VSS 0.004115f
C72 IB.n27 VSS 0.030862f
C73 IB.n28 VSS 0.19107f
C74 IB.t9 VSS 0.004115f
C75 IB.t1 VSS 0.004115f
C76 IB.n29 VSS 0.030862f
C77 IB.n30 VSS 0.104656f
C78 IB.t7 VSS 0.004115f
C79 IB.t27 VSS 0.004115f
C80 IB.n31 VSS 0.030862f
C81 IB.t21 VSS 0.004115f
C82 IB.t17 VSS 0.004115f
C83 IB.n32 VSS 0.031076f
C84 IB.t13 VSS 0.004115f
C85 IB.t11 VSS 0.004115f
C86 IB.n33 VSS 0.030862f
C87 IB.n34 VSS 0.19107f
C88 IB.t15 VSS 0.004115f
C89 IB.t5 VSS 0.004115f
C90 IB.n35 VSS 0.030862f
C91 IB.n36 VSS 0.104656f
C92 IB.n37 VSS 0.110107f
C93 VDD.n0 VSS 0.049573f
C94 VDD.n1 VSS 0.306574f
C95 VDD.n2 VSS 2.23868f
C96 VDD.n3 VSS 0.192938f
C97 VDD.n4 VSS 0.306574f
C98 VDD.n5 VSS 0.306574f
C99 VDD.n6 VSS 0.306574f
C100 VDD.n7 VSS 0.192897f
C101 VDD.n8 VSS 0.089952f
C102 VDD.n9 VSS 0.049573f
C103 VDD.n10 VSS 0.192897f
C104 VDD.n11 VSS 0.306574f
C105 VDD.n12 VSS 0.306574f
C106 VDD.n13 VSS 0.192897f
C107 VDD.n14 VSS 0.306574f
C108 VDD.n15 VSS 0.306574f
C109 VDD.n16 VSS 0.192897f
C110 VDD.n17 VSS 0.089952f
C111 VDD.n18 VSS 0.306574f
C112 VDD.n19 VSS 0.306574f
C113 VDD.n20 VSS 1.1241f
C114 VDD.n21 VSS 0.192938f
C115 VDD.n22 VSS 0.306574f
C116 VDD.n23 VSS 0.306574f
C117 VDD.n24 VSS 0.192897f
C118 VDD.n25 VSS 0.306574f
C119 VDD.n26 VSS 0.306574f
C120 VDD.n27 VSS 0.192897f
C121 VDD.n28 VSS 0.049573f
C122 VDD.n29 VSS 1.05642f
C123 VDD.n30 VSS 2.31564f
C124 m1_1462_560.t11 VSS 0.026311f
C125 m1_1462_560.t29 VSS 0.026311f
C126 m1_1462_560.t27 VSS 0.026311f
C127 m1_1462_560.n0 VSS 0.116136f
C128 m1_1462_560.t7 VSS 0.026311f
C129 m1_1462_560.t13 VSS 0.026311f
C130 m1_1462_560.n1 VSS 0.115831f
C131 m1_1462_560.n2 VSS 1.1702f
C132 m1_1462_560.t21 VSS 0.026311f
C133 m1_1462_560.t31 VSS 0.026311f
C134 m1_1462_560.n3 VSS 0.115831f
C135 m1_1462_560.n4 VSS 0.606967f
C136 m1_1462_560.t9 VSS 0.026311f
C137 m1_1462_560.t15 VSS 0.026311f
C138 m1_1462_560.n5 VSS 0.115831f
C139 m1_1462_560.n6 VSS 0.57105f
C140 m1_1462_560.t28 VSS -0.003771f
C141 m1_1462_560.t26 VSS -0.003771f
C142 m1_1462_560.n7 VSS 0.236416f
C143 m1_1462_560.t6 VSS -0.003771f
C144 m1_1462_560.t12 VSS -0.003771f
C145 m1_1462_560.n8 VSS 0.235841f
C146 m1_1462_560.n9 VSS 0.527239f
C147 m1_1462_560.t20 VSS -0.003771f
C148 m1_1462_560.t30 VSS -0.003771f
C149 m1_1462_560.n10 VSS 0.235841f
C150 m1_1462_560.n11 VSS 0.285624f
C151 m1_1462_560.t8 VSS -0.003771f
C152 m1_1462_560.t14 VSS -0.003771f
C153 m1_1462_560.n12 VSS 0.235841f
C154 m1_1462_560.n13 VSS 0.249708f
C155 m1_1462_560.t2 VSS -0.003771f
C156 m1_1462_560.t4 VSS -0.003771f
C157 m1_1462_560.n14 VSS 0.236416f
C158 m1_1462_560.t18 VSS -0.003771f
C159 m1_1462_560.t24 VSS -0.003771f
C160 m1_1462_560.n15 VSS 0.235841f
C161 m1_1462_560.n16 VSS 0.527239f
C162 m1_1462_560.t0 VSS -0.003771f
C163 m1_1462_560.t10 VSS -0.003771f
C164 m1_1462_560.n17 VSS 0.235841f
C165 m1_1462_560.n18 VSS 0.285624f
C166 m1_1462_560.t16 VSS -0.003771f
C167 m1_1462_560.t22 VSS -0.003771f
C168 m1_1462_560.n19 VSS 0.235841f
C169 m1_1462_560.n20 VSS 0.249708f
C170 m1_1462_560.n21 VSS 0.074305f
C171 m1_1462_560.t34 VSS -0.004698f
C172 m1_1462_560.n22 VSS 0.032888f
C173 m1_1462_560.n23 VSS 0.095846f
C174 m1_1462_560.t33 VSS -0.004698f
C175 m1_1462_560.n24 VSS 0.032888f
C176 m1_1462_560.n25 VSS 0.095846f
C177 m1_1462_560.n26 VSS 0.031813f
C178 m1_1462_560.t41 VSS -0.004698f
C179 m1_1462_560.n27 VSS 0.032888f
C180 m1_1462_560.n28 VSS 0.095846f
C181 m1_1462_560.t44 VSS -0.004698f
C182 m1_1462_560.n29 VSS 0.032888f
C183 m1_1462_560.n30 VSS 0.095846f
C184 m1_1462_560.n31 VSS 0.031238f
C185 m1_1462_560.n32 VSS 0.527239f
C186 m1_1462_560.t32 VSS -0.004698f
C187 m1_1462_560.n33 VSS 0.032888f
C188 m1_1462_560.n34 VSS 0.095846f
C189 m1_1462_560.t37 VSS -0.004698f
C190 m1_1462_560.n35 VSS 0.032888f
C191 m1_1462_560.n36 VSS 0.095846f
C192 m1_1462_560.n37 VSS 0.031238f
C193 m1_1462_560.n38 VSS 0.285624f
C194 m1_1462_560.t40 VSS -0.004698f
C195 m1_1462_560.n39 VSS 0.032888f
C196 m1_1462_560.n40 VSS 0.095846f
C197 m1_1462_560.t43 VSS -0.004698f
C198 m1_1462_560.n41 VSS 0.032888f
C199 m1_1462_560.n42 VSS 0.095846f
C200 m1_1462_560.n43 VSS 0.031238f
C201 m1_1462_560.n44 VSS 0.285624f
C202 m1_1462_560.t36 VSS -0.004698f
C203 m1_1462_560.n45 VSS 0.032888f
C204 m1_1462_560.n46 VSS 0.095846f
C205 m1_1462_560.t39 VSS -0.004698f
C206 m1_1462_560.n47 VSS 0.032888f
C207 m1_1462_560.n48 VSS 0.095846f
C208 m1_1462_560.n49 VSS 0.031238f
C209 m1_1462_560.n50 VSS 0.285624f
C210 m1_1462_560.t42 VSS -0.004698f
C211 m1_1462_560.n51 VSS 0.032888f
C212 m1_1462_560.n52 VSS 0.095846f
C213 m1_1462_560.t47 VSS -0.004698f
C214 m1_1462_560.n53 VSS 0.032888f
C215 m1_1462_560.n54 VSS 0.095846f
C216 m1_1462_560.n55 VSS 0.031238f
C217 m1_1462_560.n56 VSS 0.285624f
C218 m1_1462_560.t35 VSS -0.004698f
C219 m1_1462_560.n57 VSS 0.032888f
C220 m1_1462_560.n58 VSS 0.095846f
C221 m1_1462_560.t38 VSS -0.004698f
C222 m1_1462_560.n59 VSS 0.032888f
C223 m1_1462_560.n60 VSS 0.095846f
C224 m1_1462_560.n61 VSS 0.031238f
C225 m1_1462_560.n62 VSS 0.285624f
C226 m1_1462_560.t45 VSS -0.004698f
C227 m1_1462_560.n63 VSS 0.032888f
C228 m1_1462_560.n64 VSS 0.095846f
C229 m1_1462_560.t46 VSS -0.004698f
C230 m1_1462_560.n65 VSS 0.032888f
C231 m1_1462_560.n66 VSS 0.095846f
C232 m1_1462_560.n67 VSS 0.031238f
C233 m1_1462_560.n68 VSS 0.834423f
C234 m1_1462_560.n69 VSS 2.60317f
C235 m1_1462_560.n70 VSS 0.700343f
C236 m1_1462_560.t17 VSS 0.026311f
C237 m1_1462_560.t23 VSS 0.026311f
C238 m1_1462_560.n71 VSS 0.115831f
C239 m1_1462_560.n72 VSS 0.57105f
C240 m1_1462_560.t3 VSS 0.026311f
C241 m1_1462_560.t5 VSS 0.026311f
C242 m1_1462_560.n73 VSS 0.116136f
C243 m1_1462_560.t19 VSS 0.026311f
C244 m1_1462_560.t25 VSS 0.026311f
C245 m1_1462_560.n74 VSS 0.115831f
C246 m1_1462_560.n75 VSS 1.1702f
C247 m1_1462_560.n76 VSS 0.606967f
C248 m1_1462_560.n77 VSS 0.115831f
C249 m1_1462_560.t1 VSS 0.026311f
C250 VDD VSS 28.544218f
C251 VIP VSS 1.777506f
C252 IB VSS 14.356366f
C253 VOUT VSS 8.833722f
C254 m1_1548_1652# VSS 8.173234f
C255 VIN VSS 1.876316f
.ends
