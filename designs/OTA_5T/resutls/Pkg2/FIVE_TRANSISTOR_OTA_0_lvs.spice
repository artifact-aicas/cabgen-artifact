* NGSPICE file created from FIVE_TRANSISTOR_OTA_0.ext - technology: sky130A

.subckt DCL_PMOS_S_33011438_X8_Y1_1774868971 a_200_252# w_0_0#
X0 a_200_252# a_200_252# w_0_0# w_0_0# sky130_fd_pr__pfet_01v8 ad=0.0882 pd=0.91 as=0.0882 ps=0.91 w=0.63 l=0.15 M=16
.ends

.subckt NMOS_4T_45526871_X3_Y1_1774868972 a_147_504# a_200_252# a_230_504# a_241_1232#
X0 a_230_504# a_200_252# a_147_504# a_241_1232# sky130_fd_pr__nfet_01v8 ad=0.0882 pd=0.91 as=0.16695 ps=1.79 w=0.63 l=0.15 M=6
.ends

.subckt SCM_NMOS_53863688_X7_Y1_1774868974 a_147_504# a_200_252# a_402_504#
X0 a_147_504# a_200_252# a_200_252# a_147_504# sky130_fd_pr__nfet_01v8 ad=0.0882 pd=0.91 as=0.0882 ps=0.91 w=0.63 l=0.15 M=14
X1 a_402_504# a_200_252# a_147_504# a_147_504# sky130_fd_pr__nfet_01v8 ad=0.0882 pd=0.91 as=0.0882 ps=0.91 w=0.63 l=0.15 M=14
.ends

.subckt PMOS_S_10792591_X8_Y1_1774868973 a_200_252# w_0_0# a_230_504#
X0 a_230_504# a_200_252# w_0_0# w_0_0# sky130_fd_pr__pfet_01v8 ad=0.0882 pd=0.91 as=0.0882 ps=0.91 w=0.63 l=0.15 M=16
.ends

.subckt FIVE_TRANSISTOR_OTA_0 IB VOUT VIP VIN VSS VDD
XDCL_PMOS_S_33011438_X8_Y1_1774868971_0 m1_1462_560# VDD DCL_PMOS_S_33011438_X8_Y1_1774868971
XNMOS_4T_45526871_X3_Y1_1774868972_0 m1_1548_1652# VIN VOUT VSS NMOS_4T_45526871_X3_Y1_1774868972
XSCM_NMOS_53863688_X7_Y1_1774868974_0 VSS IB m1_1548_1652# SCM_NMOS_53863688_X7_Y1_1774868974
XNMOS_4T_45526871_X3_Y1_1774868972_1 m1_1548_1652# VIP m1_1462_560# VSS NMOS_4T_45526871_X3_Y1_1774868972
XPMOS_S_10792591_X8_Y1_1774868973_0 m1_1462_560# VDD VOUT PMOS_S_10792591_X8_Y1_1774868973
.ends
