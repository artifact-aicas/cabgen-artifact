* NGSPICE file created from FIVE_TRANSISTOR_OTA_0.ext - technology: sky130A

.subckt NMOS_4T_44724725_X4_Y1_1774868940 a_200_252# a_230_378# a_147_378# a_241_1232#
X0 a_230_378# a_200_252# a_147_378# a_241_1232# sky130_fd_pr__nfet_01v8 ad=0.2646 pd=2.17 as=0.2646 ps=2.17 w=1.89 l=0.15 M=8
.ends

.subckt SCM_NMOS_10406270_X1_Y1_1774868942 a_200_252# a_402_378# a_147_378#
X0 a_402_378# a_200_252# a_147_378# a_147_378# sky130_fd_pr__nfet_01v8 ad=0.2646 pd=2.17 as=0.2646 ps=2.17 w=1.89 l=0.15 M=2
X1 a_200_252# a_200_252# a_147_378# a_147_378# sky130_fd_pr__nfet_01v8 ad=0.2646 pd=2.17 as=0.50085 ps=4.31 w=1.89 l=0.15 M=2
.ends

.subckt PMOS_S_54676500_X6_Y1_1774868941 a_200_252# a_230_378# w_0_0#
X0 a_230_378# a_200_252# w_0_0# w_0_0# sky130_fd_pr__pfet_01v8 ad=0.2646 pd=2.17 as=0.2646 ps=2.17 w=1.89 l=0.15 M=12
.ends

.subckt DCL_PMOS_S_11026668_X6_Y1_1774868939 a_200_252# w_0_0#
X0 a_200_252# a_200_252# w_0_0# w_0_0# sky130_fd_pr__pfet_01v8 ad=0.2646 pd=2.17 as=0.2646 ps=2.17 w=1.89 l=0.15 M=12
.ends

.subckt FIVE_TRANSISTOR_OTA_0 IB VOUT VIP VIN VSS VDD
XNMOS_4T_44724725_X4_Y1_1774868940_0 VIN VOUT m1_860_1316# VSS NMOS_4T_44724725_X4_Y1_1774868940
XNMOS_4T_44724725_X4_Y1_1774868940_1 VIP m1_2032_1400# m1_860_1316# VSS NMOS_4T_44724725_X4_Y1_1774868940
XSCM_NMOS_10406270_X1_Y1_1774868942_0 IB m1_860_1316# VSS SCM_NMOS_10406270_X1_Y1_1774868942
XPMOS_S_54676500_X6_Y1_1774868941_0 m1_2032_1400# VOUT VDD PMOS_S_54676500_X6_Y1_1774868941
XDCL_PMOS_S_11026668_X6_Y1_1774868939_0 m1_2032_1400# VDD DCL_PMOS_S_11026668_X6_Y1_1774868939
.ends
