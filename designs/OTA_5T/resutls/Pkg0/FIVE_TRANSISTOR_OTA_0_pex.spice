* NGSPICE file created from FIVE_TRANSISTOR_OTA_0.ext - technology: sky130A

.subckt NMOS_4T_44724725_X4_Y1_1774868940 a_200_252# a_230_378# a_147_378# a_241_1232#
X0 a_230_378# a_200_252# a_147_378# a_241_1232# sky130_fd_pr__nfet_01v8 ad=0.2646 pd=2.17 as=0.2646 ps=2.17 w=1.89 l=0.15
X1 a_230_378# a_200_252# a_147_378# a_241_1232# sky130_fd_pr__nfet_01v8 ad=0.2646 pd=2.17 as=0.2646 ps=2.17 w=1.89 l=0.15
X2 a_147_378# a_200_252# a_230_378# a_241_1232# sky130_fd_pr__nfet_01v8 ad=0.2646 pd=2.17 as=0.2646 ps=2.17 w=1.89 l=0.15
X3 a_147_378# a_200_252# a_230_378# a_241_1232# sky130_fd_pr__nfet_01v8 ad=0.50085 pd=4.31 as=0.2646 ps=2.17 w=1.89 l=0.15
X4 a_230_378# a_200_252# a_147_378# a_241_1232# sky130_fd_pr__nfet_01v8 ad=0.2646 pd=2.17 as=0.2646 ps=2.17 w=1.89 l=0.15
X5 a_230_378# a_200_252# a_147_378# a_241_1232# sky130_fd_pr__nfet_01v8 ad=0.2646 pd=2.17 as=0.50085 ps=4.31 w=1.89 l=0.15
X6 a_147_378# a_200_252# a_230_378# a_241_1232# sky130_fd_pr__nfet_01v8 ad=0.2646 pd=2.17 as=0.2646 ps=2.17 w=1.89 l=0.15
X7 a_147_378# a_200_252# a_230_378# a_241_1232# sky130_fd_pr__nfet_01v8 ad=0.2646 pd=2.17 as=0.2646 ps=2.17 w=1.89 l=0.15
C0 a_200_252# a_147_378# 0.319909f
C1 a_147_378# a_230_378# 2.76187f
C2 a_200_252# a_230_378# 0.324704f
C3 a_230_378# a_241_1232# 0.287565f
C4 a_147_378# a_241_1232# 0.5703f
C5 a_200_252# a_241_1232# 1.53927f
.ends

.subckt SCM_NMOS_10406270_X1_Y1_1774868942 a_200_252# a_402_378# a_147_378#
X0 a_402_378# a_200_252# a_147_378# a_147_378# sky130_fd_pr__nfet_01v8 ad=0.2646 pd=2.17 as=0.2646 ps=2.17 w=1.89 l=0.15
X1 a_147_378# a_200_252# a_402_378# a_147_378# sky130_fd_pr__nfet_01v8 ad=0.50085 pd=4.31 as=0.2646 ps=2.17 w=1.89 l=0.15
X2 a_200_252# a_200_252# a_147_378# a_147_378# sky130_fd_pr__nfet_01v8 ad=0.2646 pd=2.17 as=0.50085 ps=4.31 w=1.89 l=0.15
X3 a_147_378# a_200_252# a_200_252# a_147_378# sky130_fd_pr__nfet_01v8 ad=0.2646 pd=2.17 as=0.2646 ps=2.17 w=1.89 l=0.15
C0 a_200_252# a_402_378# 0.171837f
C1 a_402_378# a_147_378# 0.889424f
C2 a_200_252# a_147_378# 2.36816f
.ends

.subckt PMOS_S_54676500_X6_Y1_1774868941 a_200_252# a_230_378# w_0_0# VSUBS
X0 a_230_378# a_200_252# w_0_0# w_0_0# sky130_fd_pr__pfet_01v8 ad=0.2646 pd=2.17 as=0.2646 ps=2.17 w=1.89 l=0.15
X1 a_230_378# a_200_252# w_0_0# w_0_0# sky130_fd_pr__pfet_01v8 ad=0.2646 pd=2.17 as=0.2646 ps=2.17 w=1.89 l=0.15
X2 w_0_0# a_200_252# a_230_378# w_0_0# sky130_fd_pr__pfet_01v8 ad=0.50085 pd=4.31 as=0.2646 ps=2.17 w=1.89 l=0.15
X3 w_0_0# a_200_252# a_230_378# w_0_0# sky130_fd_pr__pfet_01v8 ad=0.2646 pd=2.17 as=0.2646 ps=2.17 w=1.89 l=0.15
X4 w_0_0# a_200_252# a_230_378# w_0_0# sky130_fd_pr__pfet_01v8 ad=0.2646 pd=2.17 as=0.2646 ps=2.17 w=1.89 l=0.15
X5 a_230_378# a_200_252# w_0_0# w_0_0# sky130_fd_pr__pfet_01v8 ad=0.2646 pd=2.17 as=0.2646 ps=2.17 w=1.89 l=0.15
X6 a_230_378# a_200_252# w_0_0# w_0_0# sky130_fd_pr__pfet_01v8 ad=0.2646 pd=2.17 as=0.2646 ps=2.17 w=1.89 l=0.15
X7 w_0_0# a_200_252# a_230_378# w_0_0# sky130_fd_pr__pfet_01v8 ad=0.2646 pd=2.17 as=0.2646 ps=2.17 w=1.89 l=0.15
X8 a_230_378# a_200_252# w_0_0# w_0_0# sky130_fd_pr__pfet_01v8 ad=0.2646 pd=2.17 as=0.50085 ps=4.31 w=1.89 l=0.15
X9 w_0_0# a_200_252# a_230_378# w_0_0# sky130_fd_pr__pfet_01v8 ad=0.2646 pd=2.17 as=0.2646 ps=2.17 w=1.89 l=0.15
X10 w_0_0# a_200_252# a_230_378# w_0_0# sky130_fd_pr__pfet_01v8 ad=0.2646 pd=2.17 as=0.2646 ps=2.17 w=1.89 l=0.15
X11 a_230_378# a_200_252# w_0_0# w_0_0# sky130_fd_pr__pfet_01v8 ad=0.2646 pd=2.17 as=0.2646 ps=2.17 w=1.89 l=0.15
C0 w_0_0# a_200_252# 2.49527f
C1 a_200_252# a_230_378# 0.48726f
C2 w_0_0# a_230_378# 4.44478f
C3 a_230_378# VSUBS 0.244237f
C4 a_200_252# VSUBS 0.358068f
C5 w_0_0# VSUBS 6.58438f
.ends

.subckt DCL_PMOS_S_11026668_X6_Y1_1774868939 a_200_252# w_0_0# VSUBS
X0 a_200_252# a_200_252# w_0_0# w_0_0# sky130_fd_pr__pfet_01v8 ad=0.2646 pd=2.17 as=0.2646 ps=2.17 w=1.89 l=0.15
X1 a_200_252# a_200_252# w_0_0# w_0_0# sky130_fd_pr__pfet_01v8 ad=0.2646 pd=2.17 as=0.2646 ps=2.17 w=1.89 l=0.15
X2 w_0_0# a_200_252# a_200_252# w_0_0# sky130_fd_pr__pfet_01v8 ad=0.50085 pd=4.31 as=0.2646 ps=2.17 w=1.89 l=0.15
X3 w_0_0# a_200_252# a_200_252# w_0_0# sky130_fd_pr__pfet_01v8 ad=0.2646 pd=2.17 as=0.2646 ps=2.17 w=1.89 l=0.15
X4 w_0_0# a_200_252# a_200_252# w_0_0# sky130_fd_pr__pfet_01v8 ad=0.2646 pd=2.17 as=0.2646 ps=2.17 w=1.89 l=0.15
X5 a_200_252# a_200_252# w_0_0# w_0_0# sky130_fd_pr__pfet_01v8 ad=0.2646 pd=2.17 as=0.2646 ps=2.17 w=1.89 l=0.15
X6 a_200_252# a_200_252# w_0_0# w_0_0# sky130_fd_pr__pfet_01v8 ad=0.2646 pd=2.17 as=0.2646 ps=2.17 w=1.89 l=0.15
X7 w_0_0# a_200_252# a_200_252# w_0_0# sky130_fd_pr__pfet_01v8 ad=0.2646 pd=2.17 as=0.2646 ps=2.17 w=1.89 l=0.15
X8 a_200_252# a_200_252# w_0_0# w_0_0# sky130_fd_pr__pfet_01v8 ad=0.2646 pd=2.17 as=0.50085 ps=4.31 w=1.89 l=0.15
X9 w_0_0# a_200_252# a_200_252# w_0_0# sky130_fd_pr__pfet_01v8 ad=0.2646 pd=2.17 as=0.2646 ps=2.17 w=1.89 l=0.15
X10 w_0_0# a_200_252# a_200_252# w_0_0# sky130_fd_pr__pfet_01v8 ad=0.2646 pd=2.17 as=0.2646 ps=2.17 w=1.89 l=0.15
X11 a_200_252# a_200_252# w_0_0# w_0_0# sky130_fd_pr__pfet_01v8 ad=0.2646 pd=2.17 as=0.2646 ps=2.17 w=1.89 l=0.15
C0 w_0_0# a_200_252# 7.47465f
C1 a_200_252# VSUBS 0.660972f
C2 w_0_0# VSUBS 6.59883f
.ends

.subckt FIVE_TRANSISTOR_OTA_0 IB VOUT VIP VIN VSS VDD
XNMOS_4T_44724725_X4_Y1_1774868940_0 VIN VOUT m1_860_1316# VSS NMOS_4T_44724725_X4_Y1_1774868940
XNMOS_4T_44724725_X4_Y1_1774868940_1 VIP m1_2032_1400# m1_860_1316# VSS NMOS_4T_44724725_X4_Y1_1774868940
XSCM_NMOS_10406270_X1_Y1_1774868942_0 IB m1_860_1316# VSS SCM_NMOS_10406270_X1_Y1_1774868942
XPMOS_S_54676500_X6_Y1_1774868941_0 m1_2032_1400# VOUT VDD VSS PMOS_S_54676500_X6_Y1_1774868941
XDCL_PMOS_S_11026668_X6_Y1_1774868939_0 m1_2032_1400# VDD VSS DCL_PMOS_S_11026668_X6_Y1_1774868939
R0 VIN.n3 VIN.t3 294.913
R1 VIN.n3 VIN.t1 294.913
R2 VIN.n4 VIN.t7 294.913
R3 VIN.n4 VIN.t4 294.913
R4 VIN.n1 VIN.t2 294.913
R5 VIN.n1 VIN.t0 294.913
R6 VIN.n0 VIN.t6 294.913
R7 VIN.n0 VIN.t5 294.913
R8 VIN.n5 VIN.n3 161.685
R9 VIN.n2 VIN.n0 161.685
R10 VIN.n5 VIN.n4 161.3
R11 VIN.n2 VIN.n1 161.3
R12 VIN VIN.n2 0.192464
R13 VIN VIN.n5 0.192464
R14 VSS.n17 VSS.n16 2152.98
R15 VSS.n16 VSS.n15 1470.81
R16 VSS.n14 VSS.n13 1179.68
R17 VSS.n13 VSS.n12 1179.3
R18 VSS.n9 VSS.n2 1179.3
R19 VSS.n6 VSS.n5 1179.3
R20 VSS.n16 VSS 500.262
R21 VSS.n3 VSS.n1 232.148
R22 VSS.n11 VSS.n10 232.148
R23 VSS.n8 VSS.n7 232.148
R24 VSS.n15 VSS.n14 116.075
R25 VSS.n14 VSS.n1 116.075
R26 VSS.n12 VSS.n3 116.075
R27 VSS.n12 VSS.n11 116.075
R28 VSS.n10 VSS.n9 116.075
R29 VSS.n9 VSS.n8 116.075
R30 VSS.n7 VSS.n6 116.075
R31 VSS.n6 VSS.n4 116.075
R32 VSS.n5 VSS.n0 11.8267
R33 VSS VSS.n0 3.973
R34 VSS VSS.n17 3.70072
R35 VSS.n13 VSS.n2 0.384429
R36 VSS.n5 VSS.n2 0.384429
R37 VSS.n17 VSS.n0 0.152075
R38 VIP.n3 VIP.t6 568.582
R39 VIP.n3 VIP.t5 568.582
R40 VIP.n4 VIP.t2 568.582
R41 VIP.n4 VIP.t0 568.582
R42 VIP.n1 VIP.t7 568.582
R43 VIP.n1 VIP.t4 568.582
R44 VIP.n0 VIP.t3 568.582
R45 VIP.n0 VIP.t1 568.582
R46 VIP.n5 VIP.n3 161.685
R47 VIP.n2 VIP.n0 161.685
R48 VIP.n5 VIP.n4 161.3
R49 VIP.n2 VIP.n1 161.3
R50 VIP VIP.n2 0.192464
R51 VIP VIP.n5 0.192464
R52 m1_2032_1400.n10 m1_2032_1400.t6 568.582
R53 m1_2032_1400.n10 m1_2032_1400.t4 568.582
R54 m1_2032_1400.n11 m1_2032_1400.t22 568.582
R55 m1_2032_1400.n11 m1_2032_1400.t16 568.582
R56 m1_2032_1400.n13 m1_2032_1400.t10 568.582
R57 m1_2032_1400.n13 m1_2032_1400.t2 568.582
R58 m1_2032_1400.n8 m1_2032_1400.t20 568.582
R59 m1_2032_1400.n8 m1_2032_1400.t14 568.582
R60 m1_2032_1400.n6 m1_2032_1400.t12 568.582
R61 m1_2032_1400.n6 m1_2032_1400.t8 568.582
R62 m1_2032_1400.n5 m1_2032_1400.t0 568.582
R63 m1_2032_1400.n5 m1_2032_1400.t18 568.582
R64 m1_2032_1400.n16 m1_2032_1400.t26 568.582
R65 m1_2032_1400.n16 m1_2032_1400.t35 568.582
R66 m1_2032_1400.n17 m1_2032_1400.t31 568.582
R67 m1_2032_1400.n17 m1_2032_1400.t29 568.582
R68 m1_2032_1400.n19 m1_2032_1400.t28 568.582
R69 m1_2032_1400.n19 m1_2032_1400.t25 568.582
R70 m1_2032_1400.n21 m1_2032_1400.t34 568.582
R71 m1_2032_1400.n21 m1_2032_1400.t30 568.582
R72 m1_2032_1400.n23 m1_2032_1400.t27 568.582
R73 m1_2032_1400.n23 m1_2032_1400.t24 568.582
R74 m1_2032_1400.n25 m1_2032_1400.t33 568.582
R75 m1_2032_1400.n25 m1_2032_1400.t32 568.582
R76 m1_2032_1400.n32 m1_2032_1400.n31 254.232
R77 m1_2032_1400.n2 m1_2032_1400.n0 254.232
R78 m1_2032_1400.n30 m1_2032_1400.n29 253.849
R79 m1_2032_1400.n4 m1_2032_1400.n3 253.849
R80 m1_2032_1400.n2 m1_2032_1400.n1 253.849
R81 m1_2032_1400.n33 m1_2032_1400.n32 253.846
R82 m1_2032_1400.n12 m1_2032_1400.n10 161.685
R83 m1_2032_1400.n7 m1_2032_1400.n5 161.685
R84 m1_2032_1400.n18 m1_2032_1400.n16 161.685
R85 m1_2032_1400.n12 m1_2032_1400.n11 161.3
R86 m1_2032_1400.n14 m1_2032_1400.n13 161.3
R87 m1_2032_1400.n9 m1_2032_1400.n8 161.3
R88 m1_2032_1400.n7 m1_2032_1400.n6 161.3
R89 m1_2032_1400.n18 m1_2032_1400.n17 161.3
R90 m1_2032_1400.n20 m1_2032_1400.n19 161.3
R91 m1_2032_1400.n22 m1_2032_1400.n21 161.3
R92 m1_2032_1400.n24 m1_2032_1400.n23 161.3
R93 m1_2032_1400.n26 m1_2032_1400.n25 161.3
R94 m1_2032_1400.n27 m1_2032_1400.n26 15.7996
R95 m1_2032_1400.n31 m1_2032_1400.t5 14.5931
R96 m1_2032_1400.n31 m1_2032_1400.t7 14.5931
R97 m1_2032_1400.n29 m1_2032_1400.t3 14.5931
R98 m1_2032_1400.n29 m1_2032_1400.t11 14.5931
R99 m1_2032_1400.n3 m1_2032_1400.t15 14.5931
R100 m1_2032_1400.n3 m1_2032_1400.t21 14.5931
R101 m1_2032_1400.n1 m1_2032_1400.t9 14.5931
R102 m1_2032_1400.n1 m1_2032_1400.t13 14.5931
R103 m1_2032_1400.n0 m1_2032_1400.t19 14.5931
R104 m1_2032_1400.n0 m1_2032_1400.t1 14.5931
R105 m1_2032_1400.n33 m1_2032_1400.t17 14.5931
R106 m1_2032_1400.t23 m1_2032_1400.n33 14.5931
R107 m1_2032_1400.n28 m1_2032_1400.n27 6.188
R108 m1_2032_1400.n27 m1_2032_1400.n15 4.688
R109 m1_2032_1400.n9 m1_2032_1400.n7 0.384429
R110 m1_2032_1400.n14 m1_2032_1400.n12 0.384429
R111 m1_2032_1400.n26 m1_2032_1400.n24 0.384429
R112 m1_2032_1400.n24 m1_2032_1400.n22 0.384429
R113 m1_2032_1400.n22 m1_2032_1400.n20 0.384429
R114 m1_2032_1400.n20 m1_2032_1400.n18 0.384429
R115 m1_2032_1400.n4 m1_2032_1400.n2 0.384429
R116 m1_2032_1400.n32 m1_2032_1400.n30 0.384429
R117 m1_2032_1400.n15 m1_2032_1400.n9 0.192464
R118 m1_2032_1400.n15 m1_2032_1400.n14 0.192464
R119 m1_2032_1400.n28 m1_2032_1400.n4 0.192464
R120 m1_2032_1400.n30 m1_2032_1400.n28 0.192464
R121 IB.n2 IB.t0 568.582
R122 IB.n2 IB.t2 568.582
R123 IB.n1 IB.t5 568.582
R124 IB.n1 IB.t4 568.582
R125 IB.n3 IB.n1 161.685
R126 IB.n3 IB.n2 161.3
R127 IB IB.n0 158.071
R128 IB.n0 IB.t1 8.88939
R129 IB.n0 IB.t3 8.88939
R130 IB IB.n3 5.438
C0 VIP VDD 0.158354f
C1 m1_860_1316# VDD 0.490955f
C2 IB VDD 0.15021f
C3 VIN VDD 0.180485f
C4 m1_860_1316# VOUT 0.068099f
C5 IB VOUT 0.030778f
C6 VIN VOUT 0.001698f
C7 VOUT VDD 0.3054f
C8 IB VIP 0.029285f
C9 m1_860_1316# IB 0.119248f
C10 VIN IB 0.035454f
C11 m1_2032_1400.t17 VSS 0.052242f
C12 m1_2032_1400.t19 VSS 0.052242f
C13 m1_2032_1400.t1 VSS 0.052242f
C14 m1_2032_1400.n0 VSS 0.21696f
C15 m1_2032_1400.t9 VSS 0.052242f
C16 m1_2032_1400.t13 VSS 0.052242f
C17 m1_2032_1400.n1 VSS 0.216502f
C18 m1_2032_1400.n2 VSS 0.633891f
C19 m1_2032_1400.t15 VSS 0.052242f
C20 m1_2032_1400.t21 VSS 0.052242f
C21 m1_2032_1400.n3 VSS 0.216502f
C22 m1_2032_1400.n4 VSS 0.307776f
C23 m1_2032_1400.t18 VSS 0.072136f
C24 m1_2032_1400.t0 VSS 0.072136f
C25 m1_2032_1400.n5 VSS 0.156475f
C26 m1_2032_1400.t8 VSS 0.072136f
C27 m1_2032_1400.t12 VSS 0.072136f
C28 m1_2032_1400.n6 VSS 0.156094f
C29 m1_2032_1400.n7 VSS 0.348961f
C30 m1_2032_1400.t14 VSS 0.072136f
C31 m1_2032_1400.t20 VSS 0.072136f
C32 m1_2032_1400.n8 VSS 0.156094f
C33 m1_2032_1400.n9 VSS 0.165273f
C34 m1_2032_1400.t4 VSS 0.072136f
C35 m1_2032_1400.t6 VSS 0.072136f
C36 m1_2032_1400.n10 VSS 0.156475f
C37 m1_2032_1400.t16 VSS 0.072136f
C38 m1_2032_1400.t22 VSS 0.072136f
C39 m1_2032_1400.n11 VSS 0.156094f
C40 m1_2032_1400.n12 VSS 0.348961f
C41 m1_2032_1400.t2 VSS 0.072136f
C42 m1_2032_1400.t10 VSS 0.072136f
C43 m1_2032_1400.n13 VSS 0.156094f
C44 m1_2032_1400.n14 VSS 0.165273f
C45 m1_2032_1400.n15 VSS 0.04918f
C46 m1_2032_1400.t35 VSS 0.072136f
C47 m1_2032_1400.t26 VSS 0.072136f
C48 m1_2032_1400.n16 VSS 0.156475f
C49 m1_2032_1400.t29 VSS 0.072136f
C50 m1_2032_1400.t31 VSS 0.072136f
C51 m1_2032_1400.n17 VSS 0.156094f
C52 m1_2032_1400.n18 VSS 0.348961f
C53 m1_2032_1400.t25 VSS 0.072136f
C54 m1_2032_1400.t28 VSS 0.072136f
C55 m1_2032_1400.n19 VSS 0.156094f
C56 m1_2032_1400.n20 VSS 0.189044f
C57 m1_2032_1400.t30 VSS 0.072136f
C58 m1_2032_1400.t34 VSS 0.072136f
C59 m1_2032_1400.n21 VSS 0.156094f
C60 m1_2032_1400.n22 VSS 0.189044f
C61 m1_2032_1400.t24 VSS 0.072136f
C62 m1_2032_1400.t27 VSS 0.072136f
C63 m1_2032_1400.n23 VSS 0.156094f
C64 m1_2032_1400.n24 VSS 0.189044f
C65 m1_2032_1400.t32 VSS 0.072136f
C66 m1_2032_1400.t33 VSS 0.072136f
C67 m1_2032_1400.n25 VSS 0.156094f
C68 m1_2032_1400.n26 VSS 0.518461f
C69 m1_2032_1400.n27 VSS 2.64122f
C70 m1_2032_1400.n28 VSS 0.830865f
C71 m1_2032_1400.t3 VSS 0.052242f
C72 m1_2032_1400.t11 VSS 0.052242f
C73 m1_2032_1400.n29 VSS 0.216502f
C74 m1_2032_1400.n30 VSS 0.307776f
C75 m1_2032_1400.t5 VSS 0.052242f
C76 m1_2032_1400.t7 VSS 0.052242f
C77 m1_2032_1400.n31 VSS 0.21696f
C78 m1_2032_1400.n32 VSS 0.633891f
C79 m1_2032_1400.n33 VSS 0.216502f
C80 m1_2032_1400.t23 VSS 0.052242f
C81 VDD VSS 32.78855f
C82 IB VSS 2.133449f
C83 m1_860_1316# VSS 2.45374f
C84 VIP VSS 1.667422f
C85 VOUT VSS 8.112047f
C86 VIN VSS 1.620033f
.ends
