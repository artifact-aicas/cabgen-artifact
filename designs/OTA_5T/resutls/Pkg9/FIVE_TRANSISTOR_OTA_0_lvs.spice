* NGSPICE file created from FIVE_TRANSISTOR_OTA_0.ext - technology: sky130A

.subckt PMOS_S_55262173_X3_Y1_1774869087 a_230_462# a_200_252# w_0_0#
X0 w_0_0# a_200_252# a_230_462# w_0_0# sky130_fd_pr__pfet_01v8 ad=0.147 pd=1.33 as=0.147 ps=1.33 w=1.05 l=0.15 M=6
.ends

.subckt SCM_NMOS_33182518_X10_Y1_1774869088 a_200_252# a_402_462# a_147_462#
X0 a_402_462# a_200_252# a_147_462# a_147_462# sky130_fd_pr__nfet_01v8 ad=0.147 pd=1.33 as=0.147 ps=1.33 w=1.05 l=0.15 M=20
X1 a_147_462# a_200_252# a_200_252# a_147_462# sky130_fd_pr__nfet_01v8 ad=0.27825 pd=2.63 as=0.147 ps=1.33 w=1.05 l=0.15 M=20
.ends

.subckt DCL_PMOS_S_56391010_X3_Y1_1774869085 a_200_252# w_0_0#
X0 w_0_0# a_200_252# a_200_252# w_0_0# sky130_fd_pr__pfet_01v8 ad=0.147 pd=1.33 as=0.147 ps=1.33 w=1.05 l=0.15 M=6
.ends

.subckt NMOS_4T_70086367_X5_Y1_1774869086 a_230_462# a_200_252# a_147_462# a_241_1232#
X0 a_230_462# a_200_252# a_147_462# a_241_1232# sky130_fd_pr__nfet_01v8 ad=0.147 pd=1.33 as=0.147 ps=1.33 w=1.05 l=0.15 M=10
.ends

.subckt FIVE_TRANSISTOR_OTA_0 IB VOUT VIP VIN VSS VDD
XPMOS_S_55262173_X3_Y1_1774869087_0 VOUT m1_914_1568# VDD PMOS_S_55262173_X3_Y1_1774869087
XSCM_NMOS_33182518_X10_Y1_1774869088_0 IB m1_3064_1316# VSS SCM_NMOS_33182518_X10_Y1_1774869088
XDCL_PMOS_S_56391010_X3_Y1_1774869085_0 m1_914_1568# VDD DCL_PMOS_S_56391010_X3_Y1_1774869085
XNMOS_4T_70086367_X5_Y1_1774869086_0 VOUT VIN m1_3064_1316# VSS NMOS_4T_70086367_X5_Y1_1774869086
XNMOS_4T_70086367_X5_Y1_1774869086_1 m1_914_1568# VIP m1_3064_1316# VSS NMOS_4T_70086367_X5_Y1_1774869086
.ends
