* NGSPICE file created from FIVE_TRANSISTOR_OTA_0.ext - technology: sky130A

.subckt PMOS_S_55262173_X3_Y1_1774869087 a_230_462# a_200_252# w_0_0# VSUBS
X0 w_0_0# a_200_252# a_230_462# w_0_0# sky130_fd_pr__pfet_01v8 ad=0.147 pd=1.33 as=0.147 ps=1.33 w=1.05 l=0.15
X1 a_230_462# a_200_252# w_0_0# w_0_0# sky130_fd_pr__pfet_01v8 ad=0.147 pd=1.33 as=0.147 ps=1.33 w=1.05 l=0.15
X2 a_230_462# a_200_252# w_0_0# w_0_0# sky130_fd_pr__pfet_01v8 ad=0.147 pd=1.33 as=0.27825 ps=2.63 w=1.05 l=0.15
X3 w_0_0# a_200_252# a_230_462# w_0_0# sky130_fd_pr__pfet_01v8 ad=0.147 pd=1.33 as=0.147 ps=1.33 w=1.05 l=0.15
X4 w_0_0# a_200_252# a_230_462# w_0_0# sky130_fd_pr__pfet_01v8 ad=0.27825 pd=2.63 as=0.147 ps=1.33 w=1.05 l=0.15
X5 a_230_462# a_200_252# w_0_0# w_0_0# sky130_fd_pr__pfet_01v8 ad=0.147 pd=1.33 as=0.147 ps=1.33 w=1.05 l=0.15
C0 w_0_0# a_200_252# 1.6533f
C1 a_230_462# a_200_252# 0.277781f
C2 a_230_462# w_0_0# 2.21933f
C3 a_230_462# VSUBS 0.120105f
C4 a_200_252# VSUBS 0.259993f
C5 w_0_0# VSUBS 4.41221f
.ends

.subckt SCM_NMOS_33182518_X10_Y1_1774869088 a_200_252# a_402_462# a_147_462#
X0 a_402_462# a_200_252# a_147_462# a_147_462# sky130_fd_pr__nfet_01v8 ad=0.147 pd=1.33 as=0.147 ps=1.33 w=1.05 l=0.15
X1 a_147_462# a_200_252# a_200_252# a_147_462# sky130_fd_pr__nfet_01v8 ad=0.27825 pd=2.63 as=0.147 ps=1.33 w=1.05 l=0.15
X2 a_402_462# a_200_252# a_147_462# a_147_462# sky130_fd_pr__nfet_01v8 ad=0.147 pd=1.33 as=0.147 ps=1.33 w=1.05 l=0.15
X3 a_200_252# a_200_252# a_147_462# a_147_462# sky130_fd_pr__nfet_01v8 ad=0.147 pd=1.33 as=0.147 ps=1.33 w=1.05 l=0.15
X4 a_147_462# a_200_252# a_200_252# a_147_462# sky130_fd_pr__nfet_01v8 ad=0.147 pd=1.33 as=0.147 ps=1.33 w=1.05 l=0.15
X5 a_147_462# a_200_252# a_402_462# a_147_462# sky130_fd_pr__nfet_01v8 ad=0.147 pd=1.33 as=0.147 ps=1.33 w=1.05 l=0.15
X6 a_402_462# a_200_252# a_147_462# a_147_462# sky130_fd_pr__nfet_01v8 ad=0.147 pd=1.33 as=0.147 ps=1.33 w=1.05 l=0.15
X7 a_147_462# a_200_252# a_200_252# a_147_462# sky130_fd_pr__nfet_01v8 ad=0.147 pd=1.33 as=0.147 ps=1.33 w=1.05 l=0.15
X8 a_200_252# a_200_252# a_147_462# a_147_462# sky130_fd_pr__nfet_01v8 ad=0.147 pd=1.33 as=0.147 ps=1.33 w=1.05 l=0.15
X9 a_200_252# a_200_252# a_147_462# a_147_462# sky130_fd_pr__nfet_01v8 ad=0.147 pd=1.33 as=0.147 ps=1.33 w=1.05 l=0.15
X10 a_147_462# a_200_252# a_402_462# a_147_462# sky130_fd_pr__nfet_01v8 ad=0.147 pd=1.33 as=0.147 ps=1.33 w=1.05 l=0.15
X11 a_402_462# a_200_252# a_147_462# a_147_462# sky130_fd_pr__nfet_01v8 ad=0.147 pd=1.33 as=0.147 ps=1.33 w=1.05 l=0.15
X12 a_147_462# a_200_252# a_402_462# a_147_462# sky130_fd_pr__nfet_01v8 ad=0.147 pd=1.33 as=0.147 ps=1.33 w=1.05 l=0.15
X13 a_200_252# a_200_252# a_147_462# a_147_462# sky130_fd_pr__nfet_01v8 ad=0.147 pd=1.33 as=0.147 ps=1.33 w=1.05 l=0.15
X14 a_402_462# a_200_252# a_147_462# a_147_462# sky130_fd_pr__nfet_01v8 ad=0.147 pd=1.33 as=0.147 ps=1.33 w=1.05 l=0.15
X15 a_147_462# a_200_252# a_402_462# a_147_462# sky130_fd_pr__nfet_01v8 ad=0.147 pd=1.33 as=0.147 ps=1.33 w=1.05 l=0.15
X16 a_200_252# a_200_252# a_147_462# a_147_462# sky130_fd_pr__nfet_01v8 ad=0.147 pd=1.33 as=0.147 ps=1.33 w=1.05 l=0.15
X17 a_147_462# a_200_252# a_402_462# a_147_462# sky130_fd_pr__nfet_01v8 ad=0.147 pd=1.33 as=0.147 ps=1.33 w=1.05 l=0.15
X18 a_402_462# a_200_252# a_147_462# a_147_462# sky130_fd_pr__nfet_01v8 ad=0.147 pd=1.33 as=0.147 ps=1.33 w=1.05 l=0.15
X19 a_147_462# a_200_252# a_200_252# a_147_462# sky130_fd_pr__nfet_01v8 ad=0.147 pd=1.33 as=0.147 ps=1.33 w=1.05 l=0.15
X20 a_200_252# a_200_252# a_147_462# a_147_462# sky130_fd_pr__nfet_01v8 ad=0.147 pd=1.33 as=0.147 ps=1.33 w=1.05 l=0.15
X21 a_147_462# a_200_252# a_200_252# a_147_462# sky130_fd_pr__nfet_01v8 ad=0.147 pd=1.33 as=0.147 ps=1.33 w=1.05 l=0.15
X22 a_147_462# a_200_252# a_402_462# a_147_462# sky130_fd_pr__nfet_01v8 ad=0.147 pd=1.33 as=0.147 ps=1.33 w=1.05 l=0.15
X23 a_402_462# a_200_252# a_147_462# a_147_462# sky130_fd_pr__nfet_01v8 ad=0.147 pd=1.33 as=0.147 ps=1.33 w=1.05 l=0.15
X24 a_147_462# a_200_252# a_200_252# a_147_462# sky130_fd_pr__nfet_01v8 ad=0.147 pd=1.33 as=0.147 ps=1.33 w=1.05 l=0.15
X25 a_402_462# a_200_252# a_147_462# a_147_462# sky130_fd_pr__nfet_01v8 ad=0.147 pd=1.33 as=0.147 ps=1.33 w=1.05 l=0.15
X26 a_147_462# a_200_252# a_200_252# a_147_462# sky130_fd_pr__nfet_01v8 ad=0.147 pd=1.33 as=0.147 ps=1.33 w=1.05 l=0.15
X27 a_147_462# a_200_252# a_402_462# a_147_462# sky130_fd_pr__nfet_01v8 ad=0.147 pd=1.33 as=0.147 ps=1.33 w=1.05 l=0.15
X28 a_147_462# a_200_252# a_200_252# a_147_462# sky130_fd_pr__nfet_01v8 ad=0.147 pd=1.33 as=0.147 ps=1.33 w=1.05 l=0.15
X29 a_200_252# a_200_252# a_147_462# a_147_462# sky130_fd_pr__nfet_01v8 ad=0.147 pd=1.33 as=0.147 ps=1.33 w=1.05 l=0.15
X30 a_147_462# a_200_252# a_200_252# a_147_462# sky130_fd_pr__nfet_01v8 ad=0.147 pd=1.33 as=0.147 ps=1.33 w=1.05 l=0.15
X31 a_200_252# a_200_252# a_147_462# a_147_462# sky130_fd_pr__nfet_01v8 ad=0.147 pd=1.33 as=0.147 ps=1.33 w=1.05 l=0.15
X32 a_147_462# a_200_252# a_402_462# a_147_462# sky130_fd_pr__nfet_01v8 ad=0.147 pd=1.33 as=0.147 ps=1.33 w=1.05 l=0.15
X33 a_200_252# a_200_252# a_147_462# a_147_462# sky130_fd_pr__nfet_01v8 ad=0.147 pd=1.33 as=0.27825 ps=2.63 w=1.05 l=0.15
X34 a_147_462# a_200_252# a_200_252# a_147_462# sky130_fd_pr__nfet_01v8 ad=0.147 pd=1.33 as=0.147 ps=1.33 w=1.05 l=0.15
X35 a_402_462# a_200_252# a_147_462# a_147_462# sky130_fd_pr__nfet_01v8 ad=0.147 pd=1.33 as=0.147 ps=1.33 w=1.05 l=0.15
X36 a_147_462# a_200_252# a_402_462# a_147_462# sky130_fd_pr__nfet_01v8 ad=0.147 pd=1.33 as=0.147 ps=1.33 w=1.05 l=0.15
X37 a_200_252# a_200_252# a_147_462# a_147_462# sky130_fd_pr__nfet_01v8 ad=0.147 pd=1.33 as=0.147 ps=1.33 w=1.05 l=0.15
X38 a_402_462# a_200_252# a_147_462# a_147_462# sky130_fd_pr__nfet_01v8 ad=0.147 pd=1.33 as=0.147 ps=1.33 w=1.05 l=0.15
X39 a_147_462# a_200_252# a_402_462# a_147_462# sky130_fd_pr__nfet_01v8 ad=0.147 pd=1.33 as=0.147 ps=1.33 w=1.05 l=0.15
C0 a_200_252# a_402_462# 3.00238f
C1 a_402_462# a_147_462# 8.5044f
C2 a_200_252# a_147_462# 18.8855f
.ends

.subckt DCL_PMOS_S_56391010_X3_Y1_1774869085 a_200_252# w_0_0# VSUBS
X0 w_0_0# a_200_252# a_200_252# w_0_0# sky130_fd_pr__pfet_01v8 ad=0.147 pd=1.33 as=0.147 ps=1.33 w=1.05 l=0.15
X1 a_200_252# a_200_252# w_0_0# w_0_0# sky130_fd_pr__pfet_01v8 ad=0.147 pd=1.33 as=0.147 ps=1.33 w=1.05 l=0.15
X2 a_200_252# a_200_252# w_0_0# w_0_0# sky130_fd_pr__pfet_01v8 ad=0.147 pd=1.33 as=0.27825 ps=2.63 w=1.05 l=0.15
X3 w_0_0# a_200_252# a_200_252# w_0_0# sky130_fd_pr__pfet_01v8 ad=0.147 pd=1.33 as=0.147 ps=1.33 w=1.05 l=0.15
X4 w_0_0# a_200_252# a_200_252# w_0_0# sky130_fd_pr__pfet_01v8 ad=0.27825 pd=2.63 as=0.147 ps=1.33 w=1.05 l=0.15
X5 a_200_252# a_200_252# w_0_0# w_0_0# sky130_fd_pr__pfet_01v8 ad=0.147 pd=1.33 as=0.147 ps=1.33 w=1.05 l=0.15
C0 w_0_0# a_200_252# 4.38836f
C1 a_200_252# VSUBS 0.497254f
C2 w_0_0# VSUBS 4.37294f
.ends

.subckt NMOS_4T_70086367_X5_Y1_1774869086 a_230_462# a_200_252# a_147_462# a_241_1232#
X0 a_230_462# a_200_252# a_147_462# a_241_1232# sky130_fd_pr__nfet_01v8 ad=0.147 pd=1.33 as=0.147 ps=1.33 w=1.05 l=0.15
X1 a_230_462# a_200_252# a_147_462# a_241_1232# sky130_fd_pr__nfet_01v8 ad=0.147 pd=1.33 as=0.147 ps=1.33 w=1.05 l=0.15
X2 a_147_462# a_200_252# a_230_462# a_241_1232# sky130_fd_pr__nfet_01v8 ad=0.147 pd=1.33 as=0.147 ps=1.33 w=1.05 l=0.15
X3 a_147_462# a_200_252# a_230_462# a_241_1232# sky130_fd_pr__nfet_01v8 ad=0.147 pd=1.33 as=0.147 ps=1.33 w=1.05 l=0.15
X4 a_230_462# a_200_252# a_147_462# a_241_1232# sky130_fd_pr__nfet_01v8 ad=0.147 pd=1.33 as=0.147 ps=1.33 w=1.05 l=0.15
X5 a_230_462# a_200_252# a_147_462# a_241_1232# sky130_fd_pr__nfet_01v8 ad=0.147 pd=1.33 as=0.147 ps=1.33 w=1.05 l=0.15
X6 a_147_462# a_200_252# a_230_462# a_241_1232# sky130_fd_pr__nfet_01v8 ad=0.27825 pd=2.63 as=0.147 ps=1.33 w=1.05 l=0.15
X7 a_230_462# a_200_252# a_147_462# a_241_1232# sky130_fd_pr__nfet_01v8 ad=0.147 pd=1.33 as=0.27825 ps=2.63 w=1.05 l=0.15
X8 a_147_462# a_200_252# a_230_462# a_241_1232# sky130_fd_pr__nfet_01v8 ad=0.147 pd=1.33 as=0.147 ps=1.33 w=1.05 l=0.15
X9 a_147_462# a_200_252# a_230_462# a_241_1232# sky130_fd_pr__nfet_01v8 ad=0.147 pd=1.33 as=0.147 ps=1.33 w=1.05 l=0.15
C0 a_200_252# a_147_462# 0.460388f
C1 a_230_462# a_147_462# 3.45985f
C2 a_230_462# a_200_252# 0.46324f
C3 a_230_462# a_241_1232# 0.403751f
C4 a_147_462# a_241_1232# 0.678246f
C5 a_200_252# a_241_1232# 2.39376f
.ends

.subckt FIVE_TRANSISTOR_OTA_0 IB VOUT VIP VIN VSS VDD
XPMOS_S_55262173_X3_Y1_1774869087_0 VOUT m1_914_1568# VDD VSS PMOS_S_55262173_X3_Y1_1774869087
XSCM_NMOS_33182518_X10_Y1_1774869088_0 IB m1_3064_1316# VSS SCM_NMOS_33182518_X10_Y1_1774869088
XDCL_PMOS_S_56391010_X3_Y1_1774869085_0 m1_914_1568# VDD VSS DCL_PMOS_S_56391010_X3_Y1_1774869085
XNMOS_4T_70086367_X5_Y1_1774869086_0 VOUT VIN m1_3064_1316# VSS NMOS_4T_70086367_X5_Y1_1774869086
XNMOS_4T_70086367_X5_Y1_1774869086_1 m1_914_1568# VIP m1_3064_1316# VSS NMOS_4T_70086367_X5_Y1_1774869086
R0 m1_914_1568.n3 m1_914_1568.t2 568.582
R1 m1_914_1568.n3 m1_914_1568.t8 568.582
R2 m1_914_1568.n2 m1_914_1568.t10 568.582
R3 m1_914_1568.n2 m1_914_1568.t0 568.582
R4 m1_914_1568.n1 m1_914_1568.t4 568.582
R5 m1_914_1568.n1 m1_914_1568.t6 568.582
R6 m1_914_1568.n8 m1_914_1568.t14 568.582
R7 m1_914_1568.n8 m1_914_1568.t15 568.582
R8 m1_914_1568.n6 m1_914_1568.t17 568.582
R9 m1_914_1568.n6 m1_914_1568.t12 568.582
R10 m1_914_1568.n5 m1_914_1568.t13 568.582
R11 m1_914_1568.n5 m1_914_1568.t16 568.582
R12 m1_914_1568.n12 m1_914_1568.n11 319.312
R13 m1_914_1568.n12 m1_914_1568.n0 319.312
R14 m1_914_1568.n13 m1_914_1568.n12 318.926
R15 m1_914_1568.n4 m1_914_1568.n3 161.685
R16 m1_914_1568.n4 m1_914_1568.n1 161.685
R17 m1_914_1568.n7 m1_914_1568.n5 161.685
R18 m1_914_1568.n4 m1_914_1568.n2 161.3
R19 m1_914_1568.n9 m1_914_1568.n8 161.3
R20 m1_914_1568.n7 m1_914_1568.n6 161.3
R21 m1_914_1568.n10 m1_914_1568.n9 46.1402
R22 m1_914_1568.n11 m1_914_1568.t9 26.2672
R23 m1_914_1568.n11 m1_914_1568.t3 26.2672
R24 m1_914_1568.n0 m1_914_1568.t7 26.2672
R25 m1_914_1568.n0 m1_914_1568.t5 26.2672
R26 m1_914_1568.n13 m1_914_1568.t1 26.2672
R27 m1_914_1568.t11 m1_914_1568.n13 26.2672
R28 m1_914_1568.n12 m1_914_1568.n10 6.188
R29 m1_914_1568.n10 m1_914_1568.n4 4.688
R30 m1_914_1568.n9 m1_914_1568.n7 0.384429
R31 IB.n86 IB.t4 573.581
R32 IB.n84 IB.t2 573.581
R33 IB.n91 IB.t43 573.581
R34 IB.n89 IB.t49 573.581
R35 IB.n97 IB.t53 573.581
R36 IB.n95 IB.t57 573.581
R37 IB.n103 IB.t30 573.581
R38 IB.n101 IB.t22 573.581
R39 IB.n109 IB.t20 573.581
R40 IB.n107 IB.t12 573.581
R41 IB.n115 IB.t41 573.581
R42 IB.n113 IB.t46 573.581
R43 IB.n121 IB.t52 573.581
R44 IB.n119 IB.t55 573.581
R45 IB.n127 IB.t36 573.581
R46 IB.n125 IB.t34 573.581
R47 IB.n133 IB.t26 573.581
R48 IB.n131 IB.t16 573.581
R49 IB.n81 IB.t56 573.581
R50 IB.n79 IB.t42 573.581
R51 IB.n75 IB.t47 573.581
R52 IB.n73 IB.t48 573.581
R53 IB.n69 IB.t24 573.581
R54 IB.n67 IB.t14 573.581
R55 IB.n63 IB.t0 573.581
R56 IB.n61 IB.t32 573.581
R57 IB.n57 IB.t50 573.581
R58 IB.n55 IB.t54 573.581
R59 IB.n51 IB.t58 573.581
R60 IB.n49 IB.t59 573.581
R61 IB.n45 IB.t28 573.581
R62 IB.n43 IB.t18 573.581
R63 IB.n39 IB.t10 573.581
R64 IB.n37 IB.t8 573.581
R65 IB.n33 IB.t40 573.581
R66 IB.n31 IB.t44 573.581
R67 IB.n27 IB.t45 573.581
R68 IB.n25 IB.t51 573.581
R69 IB.n22 IB.t6 573.581
R70 IB.n20 IB.t38 573.581
R71 IB.n2 IB.n0 186.23
R72 IB.n11 IB.n9 186.228
R73 IB.n11 IB.n10 185.077
R74 IB.n13 IB.n12 185.077
R75 IB.n15 IB.n14 185.077
R76 IB.n17 IB.n16 185.077
R77 IB.n8 IB.n7 185.077
R78 IB.n6 IB.n5 185.077
R79 IB.n4 IB.n3 185.077
R80 IB.n2 IB.n1 185.077
R81 IB.n93 IB.n87 161.685
R82 IB.n29 IB.n23 161.685
R83 IB.n93 IB.n92 161.3
R84 IB.n99 IB.n98 161.3
R85 IB.n105 IB.n104 161.3
R86 IB.n111 IB.n110 161.3
R87 IB.n117 IB.n116 161.3
R88 IB.n123 IB.n122 161.3
R89 IB.n129 IB.n128 161.3
R90 IB.n135 IB.n134 161.3
R91 IB.n136 IB.n82 161.3
R92 IB.n77 IB.n76 161.3
R93 IB.n71 IB.n70 161.3
R94 IB.n65 IB.n64 161.3
R95 IB.n59 IB.n58 161.3
R96 IB.n53 IB.n52 161.3
R97 IB.n47 IB.n46 161.3
R98 IB.n41 IB.n40 161.3
R99 IB.n35 IB.n34 161.3
R100 IB.n29 IB.n28 161.3
R101 IB.n86 IB.n85 33.7405
R102 IB.n84 IB.n83 33.7405
R103 IB.n91 IB.n90 33.7405
R104 IB.n89 IB.n88 33.7405
R105 IB.n97 IB.n96 33.7405
R106 IB.n95 IB.n94 33.7405
R107 IB.n103 IB.n102 33.7405
R108 IB.n101 IB.n100 33.7405
R109 IB.n109 IB.n108 33.7405
R110 IB.n107 IB.n106 33.7405
R111 IB.n115 IB.n114 33.7405
R112 IB.n113 IB.n112 33.7405
R113 IB.n121 IB.n120 33.7405
R114 IB.n119 IB.n118 33.7405
R115 IB.n127 IB.n126 33.7405
R116 IB.n125 IB.n124 33.7405
R117 IB.n133 IB.n132 33.7405
R118 IB.n131 IB.n130 33.7405
R119 IB.n81 IB.n80 33.7405
R120 IB.n79 IB.n78 33.7405
R121 IB.n75 IB.n74 33.7405
R122 IB.n73 IB.n72 33.7405
R123 IB.n69 IB.n68 33.7405
R124 IB.n67 IB.n66 33.7405
R125 IB.n63 IB.n62 33.7405
R126 IB.n61 IB.n60 33.7405
R127 IB.n57 IB.n56 33.7405
R128 IB.n55 IB.n54 33.7405
R129 IB.n51 IB.n50 33.7405
R130 IB.n49 IB.n48 33.7405
R131 IB.n45 IB.n44 33.7405
R132 IB.n43 IB.n42 33.7405
R133 IB.n39 IB.n38 33.7405
R134 IB.n37 IB.n36 33.7405
R135 IB.n33 IB.n32 33.7405
R136 IB.n31 IB.n30 33.7405
R137 IB.n27 IB.n26 33.7405
R138 IB.n25 IB.n24 33.7405
R139 IB.n22 IB.n21 33.7405
R140 IB.n20 IB.n19 33.7405
R141 IB.n87 IB.n84 24.9931
R142 IB.n87 IB.n86 24.9931
R143 IB.n92 IB.n89 24.9931
R144 IB.n92 IB.n91 24.9931
R145 IB.n98 IB.n95 24.9931
R146 IB.n98 IB.n97 24.9931
R147 IB.n104 IB.n101 24.9931
R148 IB.n104 IB.n103 24.9931
R149 IB.n110 IB.n107 24.9931
R150 IB.n110 IB.n109 24.9931
R151 IB.n116 IB.n113 24.9931
R152 IB.n116 IB.n115 24.9931
R153 IB.n122 IB.n119 24.9931
R154 IB.n122 IB.n121 24.9931
R155 IB.n128 IB.n125 24.9931
R156 IB.n128 IB.n127 24.9931
R157 IB.n134 IB.n131 24.9931
R158 IB.n134 IB.n133 24.9931
R159 IB.n82 IB.n79 24.9931
R160 IB.n82 IB.n81 24.9931
R161 IB.n76 IB.n73 24.9931
R162 IB.n76 IB.n75 24.9931
R163 IB.n70 IB.n67 24.9931
R164 IB.n70 IB.n69 24.9931
R165 IB.n64 IB.n61 24.9931
R166 IB.n64 IB.n63 24.9931
R167 IB.n58 IB.n55 24.9931
R168 IB.n58 IB.n57 24.9931
R169 IB.n52 IB.n49 24.9931
R170 IB.n52 IB.n51 24.9931
R171 IB.n46 IB.n43 24.9931
R172 IB.n46 IB.n45 24.9931
R173 IB.n40 IB.n37 24.9931
R174 IB.n40 IB.n39 24.9931
R175 IB.n34 IB.n31 24.9931
R176 IB.n34 IB.n33 24.9931
R177 IB.n28 IB.n25 24.9931
R178 IB.n28 IB.n27 24.9931
R179 IB.n23 IB.n20 24.9931
R180 IB.n23 IB.n22 24.9931
R181 IB.n9 IB.t3 16.0005
R182 IB.n9 IB.t5 16.0005
R183 IB.n10 IB.t23 16.0005
R184 IB.n10 IB.t31 16.0005
R185 IB.n12 IB.t13 16.0005
R186 IB.n12 IB.t21 16.0005
R187 IB.n14 IB.t35 16.0005
R188 IB.n14 IB.t37 16.0005
R189 IB.n16 IB.t17 16.0005
R190 IB.n16 IB.t27 16.0005
R191 IB.n7 IB.t15 16.0005
R192 IB.n7 IB.t25 16.0005
R193 IB.n5 IB.t33 16.0005
R194 IB.n5 IB.t1 16.0005
R195 IB.n3 IB.t19 16.0005
R196 IB.n3 IB.t29 16.0005
R197 IB.n1 IB.t9 16.0005
R198 IB.n1 IB.t11 16.0005
R199 IB.n0 IB.t39 16.0005
R200 IB.n0 IB.t7 16.0005
R201 IB IB.n18 5.438
R202 IB IB.n136 5.438
R203 IB.n6 IB.n4 1.15229
R204 IB.n15 IB.n13 1.15229
R205 IB.n18 IB.n8 0.768357
R206 IB.n35 IB.n29 0.384429
R207 IB.n41 IB.n35 0.384429
R208 IB.n47 IB.n41 0.384429
R209 IB.n53 IB.n47 0.384429
R210 IB.n59 IB.n53 0.384429
R211 IB.n65 IB.n59 0.384429
R212 IB.n71 IB.n65 0.384429
R213 IB.n77 IB.n71 0.384429
R214 IB.n136 IB.n77 0.384429
R215 IB.n136 IB.n135 0.384429
R216 IB.n135 IB.n129 0.384429
R217 IB.n129 IB.n123 0.384429
R218 IB.n123 IB.n117 0.384429
R219 IB.n117 IB.n111 0.384429
R220 IB.n111 IB.n105 0.384429
R221 IB.n105 IB.n99 0.384429
R222 IB.n99 IB.n93 0.384429
R223 IB.n4 IB.n2 0.384429
R224 IB.n8 IB.n6 0.384429
R225 IB.n18 IB.n17 0.384429
R226 IB.n17 IB.n15 0.384429
R227 IB.n13 IB.n11 0.384429
R228 VSS.n80 VSS.n79 4998.51
R229 VSS VSS.n1 4852.3
R230 VSS.n15 VSS.n14 1179.68
R231 VSS.n76 VSS.n75 1179.68
R232 VSS.n18 VSS.n14 1179.3
R233 VSS.n23 VSS.n22 1179.3
R234 VSS.n25 VSS.n24 1179.3
R235 VSS.n28 VSS.n12 1179.3
R236 VSS.n33 VSS.n32 1179.3
R237 VSS.n35 VSS.n34 1179.3
R238 VSS.n38 VSS.n10 1179.3
R239 VSS.n43 VSS.n42 1179.3
R240 VSS.n45 VSS.n44 1179.3
R241 VSS.n48 VSS.n8 1179.3
R242 VSS.n53 VSS.n52 1179.3
R243 VSS.n55 VSS.n54 1179.3
R244 VSS.n58 VSS.n6 1179.3
R245 VSS.n63 VSS.n62 1179.3
R246 VSS.n65 VSS.n64 1179.3
R247 VSS.n68 VSS.n4 1179.3
R248 VSS.n72 VSS.n71 1179.3
R249 VSS.n77 VSS.n76 1179.3
R250 VSS.n17 VSS.n16 232.148
R251 VSS.n20 VSS.n19 232.148
R252 VSS.n21 VSS.n13 232.148
R253 VSS.n27 VSS.n26 232.148
R254 VSS.n30 VSS.n29 232.148
R255 VSS.n31 VSS.n11 232.148
R256 VSS.n37 VSS.n36 232.148
R257 VSS.n40 VSS.n39 232.148
R258 VSS.n41 VSS.n9 232.148
R259 VSS.n47 VSS.n46 232.148
R260 VSS.n50 VSS.n49 232.148
R261 VSS.n51 VSS.n7 232.148
R262 VSS.n57 VSS.n56 232.148
R263 VSS.n60 VSS.n59 232.148
R264 VSS.n61 VSS.n5 232.148
R265 VSS.n67 VSS.n66 232.148
R266 VSS.n70 VSS.n69 232.148
R267 VSS.n73 VSS.n3 232.148
R268 VSS.n79 VSS.n78 188.958
R269 VSS.n16 VSS.n15 116.075
R270 VSS.n18 VSS.n17 116.075
R271 VSS.n19 VSS.n18 116.075
R272 VSS.n22 VSS.n20 116.075
R273 VSS.n22 VSS.n21 116.075
R274 VSS.n25 VSS.n13 116.075
R275 VSS.n26 VSS.n25 116.075
R276 VSS.n28 VSS.n27 116.075
R277 VSS.n29 VSS.n28 116.075
R278 VSS.n32 VSS.n30 116.075
R279 VSS.n32 VSS.n31 116.075
R280 VSS.n35 VSS.n11 116.075
R281 VSS.n36 VSS.n35 116.075
R282 VSS.n38 VSS.n37 116.075
R283 VSS.n39 VSS.n38 116.075
R284 VSS.n42 VSS.n40 116.075
R285 VSS.n42 VSS.n41 116.075
R286 VSS.n45 VSS.n9 116.075
R287 VSS.n46 VSS.n45 116.075
R288 VSS.n48 VSS.n47 116.075
R289 VSS.n49 VSS.n48 116.075
R290 VSS.n52 VSS.n50 116.075
R291 VSS.n52 VSS.n51 116.075
R292 VSS.n55 VSS.n7 116.075
R293 VSS.n56 VSS.n55 116.075
R294 VSS.n58 VSS.n57 116.075
R295 VSS.n59 VSS.n58 116.075
R296 VSS.n62 VSS.n60 116.075
R297 VSS.n62 VSS.n61 116.075
R298 VSS.n65 VSS.n5 116.075
R299 VSS.n66 VSS.n65 116.075
R300 VSS.n68 VSS.n67 116.075
R301 VSS.n69 VSS.n68 116.075
R302 VSS.n71 VSS.n70 116.075
R303 VSS.n71 VSS.n2 116.075
R304 VSS.n78 VSS.n77 116.075
R305 VSS.n77 VSS.n3 116.075
R306 VSS.n75 VSS.n73 116.075
R307 VSS.n75 VSS.n74 116.075
R308 VSS.n15 VSS.n1 107.975
R309 VSS.n79 VSS.n2 43.1907
R310 VSS.n80 VSS 14.7259
R311 VSS.n1 VSS.n0 8.09866
R312 VSS.n44 VSS 7.5005
R313 VSS.n23 VSS.n14 0.384429
R314 VSS.n24 VSS.n23 0.384429
R315 VSS.n24 VSS.n12 0.384429
R316 VSS.n33 VSS.n12 0.384429
R317 VSS.n34 VSS.n33 0.384429
R318 VSS.n34 VSS.n10 0.384429
R319 VSS.n43 VSS.n10 0.384429
R320 VSS.n44 VSS.n43 0.384429
R321 VSS.n44 VSS.n8 0.384429
R322 VSS.n53 VSS.n8 0.384429
R323 VSS.n54 VSS.n53 0.384429
R324 VSS.n54 VSS.n6 0.384429
R325 VSS.n63 VSS.n6 0.384429
R326 VSS.n64 VSS.n63 0.384429
R327 VSS.n64 VSS.n4 0.384429
R328 VSS.n72 VSS.n4 0.384429
R329 VSS.n76 VSS.n72 0.384429
R330 VSS VSS.n80 0.0762875
R331 VIN.n4 VIN.t6 568.582
R332 VIN.n4 VIN.t4 568.582
R333 VIN.n5 VIN.t3 568.582
R334 VIN.n5 VIN.t1 568.582
R335 VIN.n3 VIN.t9 568.582
R336 VIN.n3 VIN.t5 568.582
R337 VIN.n1 VIN.t2 568.582
R338 VIN.n1 VIN.t0 568.582
R339 VIN.n0 VIN.t8 568.582
R340 VIN.n0 VIN.t7 568.582
R341 VIN.n6 VIN.n4 161.685
R342 VIN.n2 VIN.n0 161.685
R343 VIN.n6 VIN.n5 161.3
R344 VIN VIN.n3 161.3
R345 VIN.n2 VIN.n1 161.3
R346 VIN VIN.n2 0.384429
R347 VIN VIN.n6 0.384429
R348 VIP.n4 VIP.t7 568.582
R349 VIP.n4 VIP.t8 568.582
R350 VIP.n5 VIP.t0 568.582
R351 VIP.n5 VIP.t2 568.582
R352 VIP.n3 VIP.t5 568.582
R353 VIP.n3 VIP.t9 568.582
R354 VIP.n1 VIP.t1 568.582
R355 VIP.n1 VIP.t3 568.582
R356 VIP.n0 VIP.t4 568.582
R357 VIP.n0 VIP.t6 568.582
R358 VIP.n6 VIP.n4 161.685
R359 VIP.n2 VIP.n0 161.685
R360 VIP.n6 VIP.n5 161.3
R361 VIP VIP.n3 161.3
R362 VIP.n2 VIP.n1 161.3
R363 VIP VIP.n2 0.384429
R364 VIP VIP.n6 0.384429
C0 VDD IB 1.000395f
C1 VIP m1_3064_1316# 9.97e-19
C2 VOUT m1_3064_1316# 0.154145f
C3 VIN VDD 0.031369f
C4 VIP IB 0.011228f
C5 IB m1_3064_1316# 0.120868f
C6 VOUT IB 0.365411f
C7 VIN m1_3064_1316# 6.37e-19
C8 VIN VOUT 2.05e-19
C9 VDD VIP 0.042167f
C10 VDD m1_3064_1316# 0.494101f
C11 VOUT VDD 0.123573f
C12 VIN IB 0.006559f
C13 VOUT VSS 6.587392f
C14 IB.t39 VSS 0.005658f
C15 IB.t7 VSS 0.005658f
C16 IB.n0 VSS 0.043431f
C17 IB.t9 VSS 0.005658f
C18 IB.t11 VSS 0.005658f
C19 IB.n1 VSS 0.043012f
C20 IB.n2 VSS 0.140583f
C21 IB.t19 VSS 0.005658f
C22 IB.t29 VSS 0.005658f
C23 IB.n3 VSS 0.043012f
C24 IB.n4 VSS 0.073303f
C25 IB.t33 VSS 0.005658f
C26 IB.t1 VSS 0.005658f
C27 IB.n5 VSS 0.043012f
C28 IB.n6 VSS 0.073303f
C29 IB.t15 VSS 0.005658f
C30 IB.t25 VSS 0.005658f
C31 IB.n7 VSS 0.043012f
C32 IB.n8 VSS 0.064035f
C33 IB.t3 VSS 0.005658f
C34 IB.t5 VSS 0.005658f
C35 IB.n9 VSS 0.043431f
C36 IB.t23 VSS 0.005658f
C37 IB.t31 VSS 0.005658f
C38 IB.n10 VSS 0.043012f
C39 IB.n11 VSS 0.140583f
C40 IB.t13 VSS 0.005658f
C41 IB.t21 VSS 0.005658f
C42 IB.n12 VSS 0.043012f
C43 IB.n13 VSS 0.073303f
C44 IB.t35 VSS 0.005658f
C45 IB.t37 VSS 0.005658f
C46 IB.n14 VSS 0.043012f
C47 IB.n15 VSS 0.073303f
C48 IB.t17 VSS 0.005658f
C49 IB.t27 VSS 0.005658f
C50 IB.n16 VSS 0.043012f
C51 IB.n17 VSS 0.054768f
C52 IB.n18 VSS 0.032299f
C53 IB.t38 VSS 0.004243f
C54 IB.n19 VSS 0.006668f
C55 IB.n20 VSS 0.012366f
C56 IB.t6 VSS 0.004243f
C57 IB.n21 VSS 0.006668f
C58 IB.n22 VSS 0.012366f
C59 IB.n23 VSS 0.004104f
C60 IB.t51 VSS 0.004243f
C61 IB.n24 VSS 0.006668f
C62 IB.n25 VSS 0.012366f
C63 IB.t45 VSS 0.004243f
C64 IB.n26 VSS 0.006668f
C65 IB.n27 VSS 0.012366f
C66 IB.n28 VSS 0.00403f
C67 IB.n29 VSS 0.068023f
C68 IB.t44 VSS 0.004243f
C69 IB.n30 VSS 0.006668f
C70 IB.n31 VSS 0.012366f
C71 IB.t40 VSS 0.004243f
C72 IB.n32 VSS 0.006668f
C73 IB.n33 VSS 0.012366f
C74 IB.n34 VSS 0.00403f
C75 IB.n35 VSS 0.036851f
C76 IB.t8 VSS 0.004243f
C77 IB.n36 VSS 0.006668f
C78 IB.n37 VSS 0.012366f
C79 IB.t10 VSS 0.004243f
C80 IB.n38 VSS 0.006668f
C81 IB.n39 VSS 0.012366f
C82 IB.n40 VSS 0.00403f
C83 IB.n41 VSS 0.036851f
C84 IB.t18 VSS 0.004243f
C85 IB.n42 VSS 0.006668f
C86 IB.n43 VSS 0.012366f
C87 IB.t28 VSS 0.004243f
C88 IB.n44 VSS 0.006668f
C89 IB.n45 VSS 0.012366f
C90 IB.n46 VSS 0.00403f
C91 IB.n47 VSS 0.036851f
C92 IB.t59 VSS 0.004243f
C93 IB.n48 VSS 0.006668f
C94 IB.n49 VSS 0.012366f
C95 IB.t58 VSS 0.004243f
C96 IB.n50 VSS 0.006668f
C97 IB.n51 VSS 0.012366f
C98 IB.n52 VSS 0.00403f
C99 IB.n53 VSS 0.036851f
C100 IB.t54 VSS 0.004243f
C101 IB.n54 VSS 0.006668f
C102 IB.n55 VSS 0.012366f
C103 IB.t50 VSS 0.004243f
C104 IB.n56 VSS 0.006668f
C105 IB.n57 VSS 0.012366f
C106 IB.n58 VSS 0.00403f
C107 IB.n59 VSS 0.036851f
C108 IB.t32 VSS 0.004243f
C109 IB.n60 VSS 0.006668f
C110 IB.n61 VSS 0.012366f
C111 IB.t0 VSS 0.004243f
C112 IB.n62 VSS 0.006668f
C113 IB.n63 VSS 0.012366f
C114 IB.n64 VSS 0.00403f
C115 IB.n65 VSS 0.036851f
C116 IB.t14 VSS 0.004243f
C117 IB.n66 VSS 0.006668f
C118 IB.n67 VSS 0.012366f
C119 IB.t24 VSS 0.004243f
C120 IB.n68 VSS 0.006668f
C121 IB.n69 VSS 0.012366f
C122 IB.n70 VSS 0.00403f
C123 IB.n71 VSS 0.036851f
C124 IB.t48 VSS 0.004243f
C125 IB.n72 VSS 0.006668f
C126 IB.n73 VSS 0.012366f
C127 IB.t47 VSS 0.004243f
C128 IB.n74 VSS 0.006668f
C129 IB.n75 VSS 0.012366f
C130 IB.n76 VSS 0.00403f
C131 IB.n77 VSS 0.036851f
C132 IB.t42 VSS 0.004243f
C133 IB.n78 VSS 0.006668f
C134 IB.n79 VSS 0.012366f
C135 IB.t56 VSS 0.004243f
C136 IB.n80 VSS 0.006668f
C137 IB.n81 VSS 0.012366f
C138 IB.n82 VSS 0.00403f
C139 IB.t2 VSS 0.004243f
C140 IB.n83 VSS 0.006668f
C141 IB.n84 VSS 0.012366f
C142 IB.t4 VSS 0.004243f
C143 IB.n85 VSS 0.006668f
C144 IB.n86 VSS 0.012366f
C145 IB.n87 VSS 0.004104f
C146 IB.t49 VSS 0.004243f
C147 IB.n88 VSS 0.006668f
C148 IB.n89 VSS 0.012366f
C149 IB.t43 VSS 0.004243f
C150 IB.n90 VSS 0.006668f
C151 IB.n91 VSS 0.012366f
C152 IB.n92 VSS 0.00403f
C153 IB.n93 VSS 0.068023f
C154 IB.t57 VSS 0.004243f
C155 IB.n94 VSS 0.006668f
C156 IB.n95 VSS 0.012366f
C157 IB.t53 VSS 0.004243f
C158 IB.n96 VSS 0.006668f
C159 IB.n97 VSS 0.012366f
C160 IB.n98 VSS 0.00403f
C161 IB.n99 VSS 0.036851f
C162 IB.t22 VSS 0.004243f
C163 IB.n100 VSS 0.006668f
C164 IB.n101 VSS 0.012366f
C165 IB.t30 VSS 0.004243f
C166 IB.n102 VSS 0.006668f
C167 IB.n103 VSS 0.012366f
C168 IB.n104 VSS 0.00403f
C169 IB.n105 VSS 0.036851f
C170 IB.t12 VSS 0.004243f
C171 IB.n106 VSS 0.006668f
C172 IB.n107 VSS 0.012366f
C173 IB.t20 VSS 0.004243f
C174 IB.n108 VSS 0.006668f
C175 IB.n109 VSS 0.012366f
C176 IB.n110 VSS 0.00403f
C177 IB.n111 VSS 0.036851f
C178 IB.t46 VSS 0.004243f
C179 IB.n112 VSS 0.006668f
C180 IB.n113 VSS 0.012366f
C181 IB.t41 VSS 0.004243f
C182 IB.n114 VSS 0.006668f
C183 IB.n115 VSS 0.012366f
C184 IB.n116 VSS 0.00403f
C185 IB.n117 VSS 0.036851f
C186 IB.t55 VSS 0.004243f
C187 IB.n118 VSS 0.006668f
C188 IB.n119 VSS 0.012366f
C189 IB.t52 VSS 0.004243f
C190 IB.n120 VSS 0.006668f
C191 IB.n121 VSS 0.012366f
C192 IB.n122 VSS 0.00403f
C193 IB.n123 VSS 0.036851f
C194 IB.t34 VSS 0.004243f
C195 IB.n124 VSS 0.006668f
C196 IB.n125 VSS 0.012366f
C197 IB.t36 VSS 0.004243f
C198 IB.n126 VSS 0.006668f
C199 IB.n127 VSS 0.012366f
C200 IB.n128 VSS 0.00403f
C201 IB.n129 VSS 0.036851f
C202 IB.t16 VSS 0.004243f
C203 IB.n130 VSS 0.006668f
C204 IB.n131 VSS 0.012366f
C205 IB.t26 VSS 0.004243f
C206 IB.n132 VSS 0.006668f
C207 IB.n133 VSS 0.012366f
C208 IB.n134 VSS 0.00403f
C209 IB.n135 VSS 0.036851f
C210 IB.n136 VSS 0.041347f
C211 m1_914_1568.t1 VSS 0.033325f
C212 m1_914_1568.t7 VSS 0.033325f
C213 m1_914_1568.t5 VSS 0.033325f
C214 m1_914_1568.n0 VSS 0.175816f
C215 m1_914_1568.t6 VSS 0.025698f
C216 m1_914_1568.t4 VSS 0.025698f
C217 m1_914_1568.n1 VSS 0.179664f
C218 m1_914_1568.t0 VSS 0.025698f
C219 m1_914_1568.t10 VSS 0.025698f
C220 m1_914_1568.n2 VSS 0.179227f
C221 m1_914_1568.t8 VSS 0.025698f
C222 m1_914_1568.t2 VSS 0.025698f
C223 m1_914_1568.n3 VSS 0.179664f
C224 m1_914_1568.n4 VSS 0.586169f
C225 m1_914_1568.t16 VSS 0.025698f
C226 m1_914_1568.t13 VSS 0.025698f
C227 m1_914_1568.n5 VSS 0.179664f
C228 m1_914_1568.t12 VSS 0.025698f
C229 m1_914_1568.t17 VSS 0.025698f
C230 m1_914_1568.n6 VSS 0.179227f
C231 m1_914_1568.n7 VSS 0.400675f
C232 m1_914_1568.t15 VSS 0.025698f
C233 m1_914_1568.t14 VSS 0.025698f
C234 m1_914_1568.n8 VSS 0.179227f
C235 m1_914_1568.n9 VSS 0.464489f
C236 m1_914_1568.n10 VSS 4.44135f
C237 m1_914_1568.t9 VSS 0.033325f
C238 m1_914_1568.t3 VSS 0.033325f
C239 m1_914_1568.n11 VSS 0.175816f
C240 m1_914_1568.n12 VSS 2.19532f
C241 m1_914_1568.n13 VSS 0.175374f
C242 m1_914_1568.t11 VSS 0.033325f
C243 m1_3064_1316# VSS 10.070042f
C244 VIP VSS 2.339839f
C245 VIN VSS 2.500451f
C246 IB VSS 18.416515f
C247 VDD VSS 22.865376f
.ends
