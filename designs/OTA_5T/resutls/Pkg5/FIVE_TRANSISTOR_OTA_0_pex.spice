* NGSPICE file created from FIVE_TRANSISTOR_OTA_0.ext - technology: sky130A

.subckt DCL_PMOS_S_9664157_X5_Y1_1774869020 a_200_252# w_0_0# VSUBS
X0 a_200_252# a_200_252# w_0_0# w_0_0# sky130_fd_pr__pfet_01v8 ad=0.2646 pd=2.17 as=0.2646 ps=2.17 w=1.89 l=0.15
X1 a_200_252# a_200_252# w_0_0# w_0_0# sky130_fd_pr__pfet_01v8 ad=0.2646 pd=2.17 as=0.2646 ps=2.17 w=1.89 l=0.15
X2 w_0_0# a_200_252# a_200_252# w_0_0# sky130_fd_pr__pfet_01v8 ad=0.2646 pd=2.17 as=0.2646 ps=2.17 w=1.89 l=0.15
X3 w_0_0# a_200_252# a_200_252# w_0_0# sky130_fd_pr__pfet_01v8 ad=0.2646 pd=2.17 as=0.2646 ps=2.17 w=1.89 l=0.15
X4 a_200_252# a_200_252# w_0_0# w_0_0# sky130_fd_pr__pfet_01v8 ad=0.2646 pd=2.17 as=0.2646 ps=2.17 w=1.89 l=0.15
X5 a_200_252# a_200_252# w_0_0# w_0_0# sky130_fd_pr__pfet_01v8 ad=0.2646 pd=2.17 as=0.2646 ps=2.17 w=1.89 l=0.15
X6 w_0_0# a_200_252# a_200_252# w_0_0# sky130_fd_pr__pfet_01v8 ad=0.50085 pd=4.31 as=0.2646 ps=2.17 w=1.89 l=0.15
X7 a_200_252# a_200_252# w_0_0# w_0_0# sky130_fd_pr__pfet_01v8 ad=0.2646 pd=2.17 as=0.50085 ps=4.31 w=1.89 l=0.15
X8 w_0_0# a_200_252# a_200_252# w_0_0# sky130_fd_pr__pfet_01v8 ad=0.2646 pd=2.17 as=0.2646 ps=2.17 w=1.89 l=0.15
X9 w_0_0# a_200_252# a_200_252# w_0_0# sky130_fd_pr__pfet_01v8 ad=0.2646 pd=2.17 as=0.2646 ps=2.17 w=1.89 l=0.15
C0 a_200_252# w_0_0# 6.2966f
C1 a_200_252# VSUBS 0.59596f
C2 w_0_0# VSUBS 5.84806f
.ends

.subckt PMOS_S_72158034_X5_Y1_1774869022 a_200_252# a_230_378# w_0_0# VSUBS
X0 a_230_378# a_200_252# w_0_0# w_0_0# sky130_fd_pr__pfet_01v8 ad=0.2646 pd=2.17 as=0.2646 ps=2.17 w=1.89 l=0.15
X1 a_230_378# a_200_252# w_0_0# w_0_0# sky130_fd_pr__pfet_01v8 ad=0.2646 pd=2.17 as=0.2646 ps=2.17 w=1.89 l=0.15
X2 w_0_0# a_200_252# a_230_378# w_0_0# sky130_fd_pr__pfet_01v8 ad=0.2646 pd=2.17 as=0.2646 ps=2.17 w=1.89 l=0.15
X3 w_0_0# a_200_252# a_230_378# w_0_0# sky130_fd_pr__pfet_01v8 ad=0.2646 pd=2.17 as=0.2646 ps=2.17 w=1.89 l=0.15
X4 a_230_378# a_200_252# w_0_0# w_0_0# sky130_fd_pr__pfet_01v8 ad=0.2646 pd=2.17 as=0.2646 ps=2.17 w=1.89 l=0.15
X5 a_230_378# a_200_252# w_0_0# w_0_0# sky130_fd_pr__pfet_01v8 ad=0.2646 pd=2.17 as=0.2646 ps=2.17 w=1.89 l=0.15
X6 w_0_0# a_200_252# a_230_378# w_0_0# sky130_fd_pr__pfet_01v8 ad=0.50085 pd=4.31 as=0.2646 ps=2.17 w=1.89 l=0.15
X7 a_230_378# a_200_252# w_0_0# w_0_0# sky130_fd_pr__pfet_01v8 ad=0.2646 pd=2.17 as=0.50085 ps=4.31 w=1.89 l=0.15
X8 w_0_0# a_200_252# a_230_378# w_0_0# sky130_fd_pr__pfet_01v8 ad=0.2646 pd=2.17 as=0.2646 ps=2.17 w=1.89 l=0.15
X9 w_0_0# a_200_252# a_230_378# w_0_0# sky130_fd_pr__pfet_01v8 ad=0.2646 pd=2.17 as=0.2646 ps=2.17 w=1.89 l=0.15
C0 w_0_0# a_230_378# 3.68954f
C1 a_200_252# a_230_378# 0.405982f
C2 a_200_252# w_0_0# 2.10204f
C3 a_230_378# VSUBS 0.20286f
C4 a_200_252# VSUBS 0.3167f
C5 w_0_0# VSUBS 5.84923f
.ends

.subckt SCM_NMOS_26075846_X10_Y1_1774869023 a_200_252# a_402_378# a_147_378#
X0 a_147_378# a_200_252# a_402_378# a_147_378# sky130_fd_pr__nfet_01v8 ad=0.2646 pd=2.17 as=0.2646 ps=2.17 w=1.89 l=0.15
X1 a_402_378# a_200_252# a_147_378# a_147_378# sky130_fd_pr__nfet_01v8 ad=0.2646 pd=2.17 as=0.2646 ps=2.17 w=1.89 l=0.15
X2 a_402_378# a_200_252# a_147_378# a_147_378# sky130_fd_pr__nfet_01v8 ad=0.2646 pd=2.17 as=0.2646 ps=2.17 w=1.89 l=0.15
X3 a_402_378# a_200_252# a_147_378# a_147_378# sky130_fd_pr__nfet_01v8 ad=0.2646 pd=2.17 as=0.2646 ps=2.17 w=1.89 l=0.15
X4 a_147_378# a_200_252# a_200_252# a_147_378# sky130_fd_pr__nfet_01v8 ad=0.50085 pd=4.31 as=0.2646 ps=2.17 w=1.89 l=0.15
X5 a_147_378# a_200_252# a_200_252# a_147_378# sky130_fd_pr__nfet_01v8 ad=0.2646 pd=2.17 as=0.2646 ps=2.17 w=1.89 l=0.15
X6 a_200_252# a_200_252# a_147_378# a_147_378# sky130_fd_pr__nfet_01v8 ad=0.2646 pd=2.17 as=0.2646 ps=2.17 w=1.89 l=0.15
X7 a_402_378# a_200_252# a_147_378# a_147_378# sky130_fd_pr__nfet_01v8 ad=0.2646 pd=2.17 as=0.2646 ps=2.17 w=1.89 l=0.15
X8 a_147_378# a_200_252# a_402_378# a_147_378# sky130_fd_pr__nfet_01v8 ad=0.2646 pd=2.17 as=0.2646 ps=2.17 w=1.89 l=0.15
X9 a_147_378# a_200_252# a_200_252# a_147_378# sky130_fd_pr__nfet_01v8 ad=0.2646 pd=2.17 as=0.2646 ps=2.17 w=1.89 l=0.15
X10 a_200_252# a_200_252# a_147_378# a_147_378# sky130_fd_pr__nfet_01v8 ad=0.2646 pd=2.17 as=0.2646 ps=2.17 w=1.89 l=0.15
X11 a_200_252# a_200_252# a_147_378# a_147_378# sky130_fd_pr__nfet_01v8 ad=0.2646 pd=2.17 as=0.2646 ps=2.17 w=1.89 l=0.15
X12 a_147_378# a_200_252# a_402_378# a_147_378# sky130_fd_pr__nfet_01v8 ad=0.2646 pd=2.17 as=0.2646 ps=2.17 w=1.89 l=0.15
X13 a_402_378# a_200_252# a_147_378# a_147_378# sky130_fd_pr__nfet_01v8 ad=0.2646 pd=2.17 as=0.2646 ps=2.17 w=1.89 l=0.15
X14 a_147_378# a_200_252# a_402_378# a_147_378# sky130_fd_pr__nfet_01v8 ad=0.2646 pd=2.17 as=0.2646 ps=2.17 w=1.89 l=0.15
X15 a_200_252# a_200_252# a_147_378# a_147_378# sky130_fd_pr__nfet_01v8 ad=0.2646 pd=2.17 as=0.2646 ps=2.17 w=1.89 l=0.15
X16 a_402_378# a_200_252# a_147_378# a_147_378# sky130_fd_pr__nfet_01v8 ad=0.2646 pd=2.17 as=0.2646 ps=2.17 w=1.89 l=0.15
X17 a_200_252# a_200_252# a_147_378# a_147_378# sky130_fd_pr__nfet_01v8 ad=0.2646 pd=2.17 as=0.2646 ps=2.17 w=1.89 l=0.15
X18 a_147_378# a_200_252# a_402_378# a_147_378# sky130_fd_pr__nfet_01v8 ad=0.2646 pd=2.17 as=0.2646 ps=2.17 w=1.89 l=0.15
X19 a_147_378# a_200_252# a_402_378# a_147_378# sky130_fd_pr__nfet_01v8 ad=0.2646 pd=2.17 as=0.2646 ps=2.17 w=1.89 l=0.15
X20 a_147_378# a_200_252# a_200_252# a_147_378# sky130_fd_pr__nfet_01v8 ad=0.2646 pd=2.17 as=0.2646 ps=2.17 w=1.89 l=0.15
X21 a_402_378# a_200_252# a_147_378# a_147_378# sky130_fd_pr__nfet_01v8 ad=0.2646 pd=2.17 as=0.2646 ps=2.17 w=1.89 l=0.15
X22 a_200_252# a_200_252# a_147_378# a_147_378# sky130_fd_pr__nfet_01v8 ad=0.2646 pd=2.17 as=0.2646 ps=2.17 w=1.89 l=0.15
X23 a_147_378# a_200_252# a_200_252# a_147_378# sky130_fd_pr__nfet_01v8 ad=0.2646 pd=2.17 as=0.2646 ps=2.17 w=1.89 l=0.15
X24 a_147_378# a_200_252# a_402_378# a_147_378# sky130_fd_pr__nfet_01v8 ad=0.2646 pd=2.17 as=0.2646 ps=2.17 w=1.89 l=0.15
X25 a_402_378# a_200_252# a_147_378# a_147_378# sky130_fd_pr__nfet_01v8 ad=0.2646 pd=2.17 as=0.2646 ps=2.17 w=1.89 l=0.15
X26 a_147_378# a_200_252# a_200_252# a_147_378# sky130_fd_pr__nfet_01v8 ad=0.2646 pd=2.17 as=0.2646 ps=2.17 w=1.89 l=0.15
X27 a_402_378# a_200_252# a_147_378# a_147_378# sky130_fd_pr__nfet_01v8 ad=0.2646 pd=2.17 as=0.2646 ps=2.17 w=1.89 l=0.15
X28 a_147_378# a_200_252# a_200_252# a_147_378# sky130_fd_pr__nfet_01v8 ad=0.2646 pd=2.17 as=0.2646 ps=2.17 w=1.89 l=0.15
X29 a_147_378# a_200_252# a_402_378# a_147_378# sky130_fd_pr__nfet_01v8 ad=0.2646 pd=2.17 as=0.2646 ps=2.17 w=1.89 l=0.15
X30 a_147_378# a_200_252# a_200_252# a_147_378# sky130_fd_pr__nfet_01v8 ad=0.2646 pd=2.17 as=0.2646 ps=2.17 w=1.89 l=0.15
X31 a_200_252# a_200_252# a_147_378# a_147_378# sky130_fd_pr__nfet_01v8 ad=0.2646 pd=2.17 as=0.2646 ps=2.17 w=1.89 l=0.15
X32 a_147_378# a_200_252# a_200_252# a_147_378# sky130_fd_pr__nfet_01v8 ad=0.2646 pd=2.17 as=0.2646 ps=2.17 w=1.89 l=0.15
X33 a_200_252# a_200_252# a_147_378# a_147_378# sky130_fd_pr__nfet_01v8 ad=0.2646 pd=2.17 as=0.2646 ps=2.17 w=1.89 l=0.15
X34 a_147_378# a_200_252# a_402_378# a_147_378# sky130_fd_pr__nfet_01v8 ad=0.2646 pd=2.17 as=0.2646 ps=2.17 w=1.89 l=0.15
X35 a_200_252# a_200_252# a_147_378# a_147_378# sky130_fd_pr__nfet_01v8 ad=0.2646 pd=2.17 as=0.50085 ps=4.31 w=1.89 l=0.15
X36 a_402_378# a_200_252# a_147_378# a_147_378# sky130_fd_pr__nfet_01v8 ad=0.2646 pd=2.17 as=0.2646 ps=2.17 w=1.89 l=0.15
X37 a_147_378# a_200_252# a_200_252# a_147_378# sky130_fd_pr__nfet_01v8 ad=0.2646 pd=2.17 as=0.2646 ps=2.17 w=1.89 l=0.15
X38 a_147_378# a_200_252# a_402_378# a_147_378# sky130_fd_pr__nfet_01v8 ad=0.2646 pd=2.17 as=0.2646 ps=2.17 w=1.89 l=0.15
X39 a_200_252# a_200_252# a_147_378# a_147_378# sky130_fd_pr__nfet_01v8 ad=0.2646 pd=2.17 as=0.2646 ps=2.17 w=1.89 l=0.15
C0 a_402_378# a_200_252# 2.88868f
C1 a_402_378# a_147_378# 8.43576f
C2 a_200_252# a_147_378# 16.6929f
.ends

.subckt NMOS_4T_39571376_X7_Y1_1774869021 a_200_252# a_230_378# a_147_378# a_241_1232#
X0 a_230_378# a_200_252# a_147_378# a_241_1232# sky130_fd_pr__nfet_01v8 ad=0.2646 pd=2.17 as=0.2646 ps=2.17 w=1.89 l=0.15
X1 a_230_378# a_200_252# a_147_378# a_241_1232# sky130_fd_pr__nfet_01v8 ad=0.2646 pd=2.17 as=0.2646 ps=2.17 w=1.89 l=0.15
X2 a_230_378# a_200_252# a_147_378# a_241_1232# sky130_fd_pr__nfet_01v8 ad=0.2646 pd=2.17 as=0.2646 ps=2.17 w=1.89 l=0.15
X3 a_147_378# a_200_252# a_230_378# a_241_1232# sky130_fd_pr__nfet_01v8 ad=0.2646 pd=2.17 as=0.2646 ps=2.17 w=1.89 l=0.15
X4 a_147_378# a_200_252# a_230_378# a_241_1232# sky130_fd_pr__nfet_01v8 ad=0.2646 pd=2.17 as=0.2646 ps=2.17 w=1.89 l=0.15
X5 a_147_378# a_200_252# a_230_378# a_241_1232# sky130_fd_pr__nfet_01v8 ad=0.2646 pd=2.17 as=0.2646 ps=2.17 w=1.89 l=0.15
X6 a_230_378# a_200_252# a_147_378# a_241_1232# sky130_fd_pr__nfet_01v8 ad=0.2646 pd=2.17 as=0.2646 ps=2.17 w=1.89 l=0.15
X7 a_230_378# a_200_252# a_147_378# a_241_1232# sky130_fd_pr__nfet_01v8 ad=0.2646 pd=2.17 as=0.2646 ps=2.17 w=1.89 l=0.15
X8 a_230_378# a_200_252# a_147_378# a_241_1232# sky130_fd_pr__nfet_01v8 ad=0.2646 pd=2.17 as=0.2646 ps=2.17 w=1.89 l=0.15
X9 a_147_378# a_200_252# a_230_378# a_241_1232# sky130_fd_pr__nfet_01v8 ad=0.2646 pd=2.17 as=0.2646 ps=2.17 w=1.89 l=0.15
X10 a_147_378# a_200_252# a_230_378# a_241_1232# sky130_fd_pr__nfet_01v8 ad=0.50085 pd=4.31 as=0.2646 ps=2.17 w=1.89 l=0.15
X11 a_230_378# a_200_252# a_147_378# a_241_1232# sky130_fd_pr__nfet_01v8 ad=0.2646 pd=2.17 as=0.50085 ps=4.31 w=1.89 l=0.15
X12 a_147_378# a_200_252# a_230_378# a_241_1232# sky130_fd_pr__nfet_01v8 ad=0.2646 pd=2.17 as=0.2646 ps=2.17 w=1.89 l=0.15
X13 a_147_378# a_200_252# a_230_378# a_241_1232# sky130_fd_pr__nfet_01v8 ad=0.2646 pd=2.17 as=0.2646 ps=2.17 w=1.89 l=0.15
C0 a_200_252# a_230_378# 0.568539f
C1 a_147_378# a_230_378# 4.88163f
C2 a_147_378# a_200_252# 0.568868f
C3 a_230_378# a_241_1232# 0.505229f
C4 a_147_378# a_241_1232# 0.706418f
C5 a_200_252# a_241_1232# 2.56166f
.ends

.subckt FIVE_TRANSISTOR_OTA_0 IB VOUT VIP VIN VSS VDD
XDCL_PMOS_S_9664157_X5_Y1_1774869020_0 li_1695_571# VDD VSS DCL_PMOS_S_9664157_X5_Y1_1774869020
XPMOS_S_72158034_X5_Y1_1774869022_0 li_1695_571# VOUT VDD VSS PMOS_S_72158034_X5_Y1_1774869022
XSCM_NMOS_26075846_X10_Y1_1774869023_0 IB m1_1634_1652# VSS SCM_NMOS_26075846_X10_Y1_1774869023
XNMOS_4T_39571376_X7_Y1_1774869021_0 VIN VOUT m1_1634_1652# VSS NMOS_4T_39571376_X7_Y1_1774869021
XNMOS_4T_39571376_X7_Y1_1774869021_1 VIP li_1695_571# m1_1634_1652# VSS NMOS_4T_39571376_X7_Y1_1774869021
R0 li_1695_571.n15 li_1695_571.t16 573.581
R1 li_1695_571.n11 li_1695_571.t0 573.581
R2 li_1695_571.n9 li_1695_571.t8 573.581
R3 li_1695_571.n5 li_1695_571.t14 573.581
R4 li_1695_571.n6 li_1695_571.t18 568.582
R5 li_1695_571.n3 li_1695_571.t4 568.582
R6 li_1695_571.n3 li_1695_571.t2 568.582
R7 li_1695_571.n26 li_1695_571.t28 568.582
R8 li_1695_571.n26 li_1695_571.t27 568.582
R9 li_1695_571.n24 li_1695_571.t22 568.582
R10 li_1695_571.n24 li_1695_571.t20 568.582
R11 li_1695_571.n22 li_1695_571.t29 568.582
R12 li_1695_571.n22 li_1695_571.t25 568.582
R13 li_1695_571.n20 li_1695_571.t23 568.582
R14 li_1695_571.n20 li_1695_571.t21 568.582
R15 li_1695_571.n19 li_1695_571.t26 568.582
R16 li_1695_571.n19 li_1695_571.t24 568.582
R17 li_1695_571.n13 li_1695_571.t6 294.913
R18 li_1695_571.n13 li_1695_571.t10 294.913
R19 li_1695_571.n16 li_1695_571.t12 294.913
R20 li_1695_571.n31 li_1695_571.n29 254.232
R21 li_1695_571.n2 li_1695_571.n0 254.232
R22 li_1695_571.n33 li_1695_571.n32 253.849
R23 li_1695_571.n31 li_1695_571.n30 253.849
R24 li_1695_571.n2 li_1695_571.n1 253.849
R25 li_1695_571.n17 li_1695_571.n13 161.685
R26 li_1695_571.n7 li_1695_571.n3 161.685
R27 li_1695_571.n21 li_1695_571.n19 161.685
R28 li_1695_571.n17 li_1695_571.n16 161.3
R29 li_1695_571.n18 li_1695_571.n12 161.3
R30 li_1695_571.n7 li_1695_571.n6 161.3
R31 li_1695_571.n27 li_1695_571.n26 161.3
R32 li_1695_571.n25 li_1695_571.n24 161.3
R33 li_1695_571.n23 li_1695_571.n22 161.3
R34 li_1695_571.n21 li_1695_571.n20 161.3
R35 li_1695_571.n28 li_1695_571.n27 46.5241
R36 li_1695_571.n15 li_1695_571.n14 33.7405
R37 li_1695_571.n11 li_1695_571.n10 33.7405
R38 li_1695_571.n9 li_1695_571.n8 33.7405
R39 li_1695_571.n5 li_1695_571.n4 33.7405
R40 li_1695_571.n16 li_1695_571.n15 24.9931
R41 li_1695_571.n12 li_1695_571.n9 24.9931
R42 li_1695_571.n12 li_1695_571.n11 24.9931
R43 li_1695_571.n6 li_1695_571.n5 24.9931
R44 li_1695_571.n29 li_1695_571.t11 14.5931
R45 li_1695_571.n29 li_1695_571.t7 14.5931
R46 li_1695_571.n30 li_1695_571.t17 14.5931
R47 li_1695_571.n30 li_1695_571.t13 14.5931
R48 li_1695_571.n1 li_1695_571.t19 14.5931
R49 li_1695_571.n1 li_1695_571.t15 14.5931
R50 li_1695_571.n0 li_1695_571.t5 14.5931
R51 li_1695_571.n0 li_1695_571.t3 14.5931
R52 li_1695_571.n33 li_1695_571.t9 14.5931
R53 li_1695_571.t1 li_1695_571.n33 14.5931
R54 li_1695_571.n32 li_1695_571.n28 6.188
R55 li_1695_571.n28 li_1695_571.n18 4.688
R56 li_1695_571.n18 li_1695_571.n7 0.384429
R57 li_1695_571.n18 li_1695_571.n17 0.384429
R58 li_1695_571.n23 li_1695_571.n21 0.384429
R59 li_1695_571.n25 li_1695_571.n23 0.384429
R60 li_1695_571.n27 li_1695_571.n25 0.384429
R61 li_1695_571.n32 li_1695_571.n2 0.384429
R62 li_1695_571.n32 li_1695_571.n31 0.384429
R63 VDD.n10 VDD.n0 583.948
R64 VDD.n8 VDD.n4 379.685
R65 VDD.n8 VDD.n7 379.3
R66 VDD.n7 VDD.n0 192.109
R67 VDD.n9 VDD.n0 90.2568
R68 VDD.n6 VDD.n5 54.0349
R69 VDD.n3 VDD.n2 54.0349
R70 VDD.n2 VDD.n1 54.0349
R71 VDD.n7 VDD.n6 27.0177
R72 VDD.n5 VDD.n4 27.0177
R73 VDD.n4 VDD.n3 27.0177
R74 VDD.n10 VDD 13.2762
R75 VDD VDD.n9 4.59425
R76 VDD VDD.n10 3.93746
R77 VDD.n9 VDD.n8 0.192464
R78 IB.n20 IB.t4 568.582
R79 IB.n20 IB.t2 568.582
R80 IB.n21 IB.t44 568.582
R81 IB.n21 IB.t51 568.582
R82 IB.n23 IB.t55 568.582
R83 IB.n23 IB.t59 568.582
R84 IB.n25 IB.t30 568.582
R85 IB.n25 IB.t22 568.582
R86 IB.n27 IB.t20 568.582
R87 IB.n27 IB.t12 568.582
R88 IB.n29 IB.t43 568.582
R89 IB.n29 IB.t48 568.582
R90 IB.n31 IB.t54 568.582
R91 IB.n31 IB.t57 568.582
R92 IB.n33 IB.t34 568.582
R93 IB.n33 IB.t36 568.582
R94 IB.n35 IB.t26 568.582
R95 IB.n35 IB.t16 568.582
R96 IB.n19 IB.t58 568.582
R97 IB.n19 IB.t45 568.582
R98 IB.n17 IB.t49 568.582
R99 IB.n17 IB.t50 568.582
R100 IB.n15 IB.t24 568.582
R101 IB.n15 IB.t14 568.582
R102 IB.n13 IB.t0 568.582
R103 IB.n13 IB.t32 568.582
R104 IB.n11 IB.t52 568.582
R105 IB.n11 IB.t56 568.582
R106 IB.n9 IB.t41 568.582
R107 IB.n9 IB.t40 568.582
R108 IB.n7 IB.t28 568.582
R109 IB.n7 IB.t18 568.582
R110 IB.n5 IB.t10 568.582
R111 IB.n5 IB.t8 568.582
R112 IB.n3 IB.t42 568.582
R113 IB.n3 IB.t46 568.582
R114 IB.n1 IB.t47 568.582
R115 IB.n1 IB.t53 568.582
R116 IB.n0 IB.t6 568.582
R117 IB.n0 IB.t38 568.582
R118 IB.n22 IB.n20 161.685
R119 IB.n2 IB.n0 161.685
R120 IB.n22 IB.n21 161.3
R121 IB.n24 IB.n23 161.3
R122 IB.n26 IB.n25 161.3
R123 IB.n28 IB.n27 161.3
R124 IB.n30 IB.n29 161.3
R125 IB.n32 IB.n31 161.3
R126 IB.n34 IB.n33 161.3
R127 IB.n36 IB.n35 161.3
R128 IB.n37 IB.n19 161.3
R129 IB.n18 IB.n17 161.3
R130 IB.n16 IB.n15 161.3
R131 IB.n14 IB.n13 161.3
R132 IB.n12 IB.n11 161.3
R133 IB.n10 IB.n9 161.3
R134 IB.n8 IB.n7 161.3
R135 IB.n6 IB.n5 161.3
R136 IB.n4 IB.n3 161.3
R137 IB.n2 IB.n1 161.3
R138 IB.n49 IB.n47 153.785
R139 IB.n40 IB.n38 153.785
R140 IB.n49 IB.n48 152.633
R141 IB.n51 IB.n50 152.633
R142 IB.n53 IB.n52 152.633
R143 IB.n55 IB.n54 152.633
R144 IB.n46 IB.n45 152.633
R145 IB.n44 IB.n43 152.633
R146 IB.n42 IB.n41 152.633
R147 IB.n40 IB.n39 152.633
R148 IB.n47 IB.t3 8.88939
R149 IB.n47 IB.t5 8.88939
R150 IB.n48 IB.t23 8.88939
R151 IB.n48 IB.t31 8.88939
R152 IB.n50 IB.t13 8.88939
R153 IB.n50 IB.t21 8.88939
R154 IB.n52 IB.t37 8.88939
R155 IB.n52 IB.t35 8.88939
R156 IB.n54 IB.t17 8.88939
R157 IB.n54 IB.t27 8.88939
R158 IB.n45 IB.t15 8.88939
R159 IB.n45 IB.t25 8.88939
R160 IB.n43 IB.t33 8.88939
R161 IB.n43 IB.t1 8.88939
R162 IB.n41 IB.t19 8.88939
R163 IB.n41 IB.t29 8.88939
R164 IB.n39 IB.t9 8.88939
R165 IB.n39 IB.t11 8.88939
R166 IB.n38 IB.t39 8.88939
R167 IB.n38 IB.t7 8.88939
R168 IB IB.n37 5.438
R169 IB IB.n56 5.438
R170 IB.n44 IB.n42 1.15229
R171 IB.n53 IB.n51 1.15229
R172 IB.n56 IB.n46 0.768357
R173 IB.n4 IB.n2 0.384429
R174 IB.n6 IB.n4 0.384429
R175 IB.n8 IB.n6 0.384429
R176 IB.n10 IB.n8 0.384429
R177 IB.n12 IB.n10 0.384429
R178 IB.n14 IB.n12 0.384429
R179 IB.n16 IB.n14 0.384429
R180 IB.n18 IB.n16 0.384429
R181 IB.n37 IB.n18 0.384429
R182 IB.n37 IB.n36 0.384429
R183 IB.n36 IB.n34 0.384429
R184 IB.n34 IB.n32 0.384429
R185 IB.n32 IB.n30 0.384429
R186 IB.n30 IB.n28 0.384429
R187 IB.n28 IB.n26 0.384429
R188 IB.n26 IB.n24 0.384429
R189 IB.n24 IB.n22 0.384429
R190 IB.n42 IB.n40 0.384429
R191 IB.n46 IB.n44 0.384429
R192 IB.n56 IB.n55 0.384429
R193 IB.n55 IB.n53 0.384429
R194 IB.n51 IB.n49 0.384429
R195 VSS.n27 VSS.n26 90022
R196 VSS.n56 VSS.n55 1179.68
R197 VSS.n33 VSS.n18 1179.68
R198 VSS.n57 VSS.n56 1179.3
R199 VSS.n8 VSS.n7 1179.3
R200 VSS.n63 VSS.n62 1179.3
R201 VSS.n65 VSS.n64 1179.3
R202 VSS.n66 VSS.n1 1179.3
R203 VSS.n72 VSS.n71 1179.3
R204 VSS.n35 VSS.n34 1179.3
R205 VSS.n37 VSS.n36 1179.3
R206 VSS.n17 VSS.n16 1179.3
R207 VSS.n43 VSS.n42 1179.3
R208 VSS.n45 VSS.n44 1179.3
R209 VSS.n13 VSS.n12 1179.3
R210 VSS.n51 VSS.n50 1179.3
R211 VSS.n52 VSS.n11 1179.3
R212 VSS.n54 VSS.n53 1179.3
R213 VSS.n10 VSS.n9 1179.3
R214 VSS.n59 VSS.n58 1179.3
R215 VSS.n61 VSS.n60 1179.3
R216 VSS.n6 VSS.n5 1179.3
R217 VSS.n68 VSS.n67 1179.3
R218 VSS.n69 VSS.n2 1179.3
R219 VSS.n19 VSS.n18 1179.3
R220 VSS.n39 VSS.n38 1179.3
R221 VSS.n41 VSS.n40 1179.3
R222 VSS.n15 VSS.n14 1179.3
R223 VSS.n47 VSS.n46 1179.3
R224 VSS.n49 VSS.n48 1179.3
R225 VSS.n70 VSS.n69 533.053
R226 VSS.n35 VSS.n32 382.455
R227 VSS.n33 VSS.n32 254.75
R228 VSS.n50 VSS.n11 252.773
R229 VSS.n54 VSS.n11 252.773
R230 VSS.n71 VSS.n70 240.523
R231 VSS.n26 VSS.n25 232.148
R232 VSS.n25 VSS.n24 232.148
R233 VSS.n24 VSS.n23 232.148
R234 VSS.n21 VSS.n20 232.148
R235 VSS.n22 VSS.n21 232.148
R236 VSS.n30 VSS.n29 232.148
R237 VSS.n29 VSS.n28 232.148
R238 VSS.n28 VSS.n27 232.148
R239 VSS.n31 VSS.n22 164.663
R240 VSS.n23 VSS.n4 159.264
R241 VSS.n70 VSS.n4 137.688
R242 VSS.n34 VSS.n33 126.386
R243 VSS.n34 VSS.n19 126.386
R244 VSS.n37 VSS.n19 126.386
R245 VSS.n38 VSS.n37 126.386
R246 VSS.n38 VSS.n17 126.386
R247 VSS.n41 VSS.n17 126.386
R248 VSS.n42 VSS.n41 126.386
R249 VSS.n42 VSS.n15 126.386
R250 VSS.n45 VSS.n15 126.386
R251 VSS.n46 VSS.n45 126.386
R252 VSS.n46 VSS.n13 126.386
R253 VSS.n49 VSS.n13 126.386
R254 VSS.n50 VSS.n49 126.386
R255 VSS.n55 VSS.n54 126.386
R256 VSS.n55 VSS.n10 126.386
R257 VSS.n57 VSS.n10 126.386
R258 VSS.n58 VSS.n57 126.386
R259 VSS.n58 VSS.n8 126.386
R260 VSS.n61 VSS.n8 126.386
R261 VSS.n62 VSS.n61 126.386
R262 VSS.n62 VSS.n6 126.386
R263 VSS.n65 VSS.n6 126.386
R264 VSS.n67 VSS.n65 126.386
R265 VSS.n67 VSS.n66 126.386
R266 VSS.n66 VSS.n2 126.386
R267 VSS.n71 VSS.n2 126.386
R268 VSS.n32 VSS.n31 73.3242
R269 VSS.n4 VSS.n3 72.8839
R270 VSS.n31 VSS.n30 67.4852
R271 VSS.n48 VSS.n0 10.3733
R272 VSS.n73 VSS.n72 10.348
R273 VSS.n51 VSS 8.6255
R274 VSS VSS.n0 5.098
R275 VSS VSS.n73 3.73773
R276 VSS.n73 VSS.n0 0.429962
R277 VSS.n36 VSS.n35 0.384429
R278 VSS.n36 VSS.n16 0.384429
R279 VSS.n43 VSS.n16 0.384429
R280 VSS.n44 VSS.n43 0.384429
R281 VSS.n44 VSS.n12 0.384429
R282 VSS.n51 VSS.n12 0.384429
R283 VSS.n52 VSS.n51 0.384429
R284 VSS.n53 VSS.n52 0.384429
R285 VSS.n53 VSS.n9 0.384429
R286 VSS.n59 VSS.n9 0.384429
R287 VSS.n60 VSS.n59 0.384429
R288 VSS.n60 VSS.n5 0.384429
R289 VSS.n68 VSS.n5 0.384429
R290 VSS.n69 VSS.n68 0.384429
R291 VSS.n56 VSS.n7 0.384429
R292 VSS.n63 VSS.n7 0.384429
R293 VSS.n64 VSS.n63 0.384429
R294 VSS.n64 VSS.n1 0.384429
R295 VSS.n72 VSS.n1 0.384429
R296 VSS.n39 VSS.n18 0.384429
R297 VSS.n40 VSS.n39 0.384429
R298 VSS.n40 VSS.n14 0.384429
R299 VSS.n47 VSS.n14 0.384429
R300 VSS.n48 VSS.n47 0.384429
R301 VIN.n6 VIN.t10 568.582
R302 VIN.n6 VIN.t7 568.582
R303 VIN.n7 VIN.t3 568.582
R304 VIN.n7 VIN.t0 568.582
R305 VIN.n9 VIN.t9 568.582
R306 VIN.n9 VIN.t6 568.582
R307 VIN.n5 VIN.t5 568.582
R308 VIN.n5 VIN.t2 568.582
R309 VIN.n3 VIN.t13 568.582
R310 VIN.n3 VIN.t8 568.582
R311 VIN.n1 VIN.t4 568.582
R312 VIN.n1 VIN.t1 568.582
R313 VIN.n0 VIN.t12 568.582
R314 VIN.n0 VIN.t11 568.582
R315 VIN.n8 VIN.n6 161.685
R316 VIN.n2 VIN.n0 161.685
R317 VIN.n8 VIN.n7 161.3
R318 VIN.n10 VIN.n9 161.3
R319 VIN VIN.n5 161.3
R320 VIN.n4 VIN.n3 161.3
R321 VIN.n2 VIN.n1 161.3
R322 VIN.n4 VIN.n2 0.384429
R323 VIN VIN.n4 0.384429
R324 VIN VIN.n10 0.384429
R325 VIN.n10 VIN.n8 0.384429
R326 VIP.n6 VIP.t11 568.582
R327 VIP.n6 VIP.t12 568.582
R328 VIP.n7 VIP.t1 568.582
R329 VIP.n7 VIP.t4 568.582
R330 VIP.n9 VIP.t8 568.582
R331 VIP.n9 VIP.t13 568.582
R332 VIP.n5 VIP.t2 568.582
R333 VIP.n5 VIP.t5 568.582
R334 VIP.n3 VIP.t6 568.582
R335 VIP.n3 VIP.t9 568.582
R336 VIP.n1 VIP.t0 568.582
R337 VIP.n1 VIP.t3 568.582
R338 VIP.n0 VIP.t7 568.582
R339 VIP.n0 VIP.t10 568.582
R340 VIP.n8 VIP.n6 161.685
R341 VIP.n2 VIP.n0 161.685
R342 VIP.n8 VIP.n7 161.3
R343 VIP.n10 VIP.n9 161.3
R344 VIP VIP.n5 161.3
R345 VIP.n4 VIP.n3 161.3
R346 VIP.n2 VIP.n1 161.3
R347 VIP.n4 VIP.n2 0.384429
R348 VIP VIP.n4 0.384429
R349 VIP VIP.n10 0.384429
R350 VIP.n10 VIP.n8 0.384429
C0 VOUT IB 2.28e-20
C1 VIN IB 0.010608f
C2 VIN VIP 0.029285f
C3 VDD m1_1634_1652# 0.470785f
C4 VOUT VIN 0.002527f
C5 VDD IB 0.677723f
C6 m1_1634_1652# IB 0.136373f
C7 VDD VIP 0.054553f
C8 VIP m1_1634_1652# 0.032943f
C9 VOUT VDD 0.217716f
C10 VOUT m1_1634_1652# 0.009876f
C11 VDD VIN 0.111076f
C12 VIP IB 0.010588f
C13 VIN m1_1634_1652# 0.006256f
C14 IB.t38 VSS 0.012262f
C15 IB.t6 VSS 0.012262f
C16 IB.n0 VSS 0.026597f
C17 IB.t53 VSS 0.012262f
C18 IB.t47 VSS 0.012262f
C19 IB.n1 VSS 0.026533f
C20 IB.n2 VSS 0.059316f
C21 IB.t46 VSS 0.012262f
C22 IB.t42 VSS 0.012262f
C23 IB.n3 VSS 0.026533f
C24 IB.n4 VSS 0.032134f
C25 IB.t8 VSS 0.012262f
C26 IB.t10 VSS 0.012262f
C27 IB.n5 VSS 0.026533f
C28 IB.n6 VSS 0.032134f
C29 IB.t18 VSS 0.012262f
C30 IB.t28 VSS 0.012262f
C31 IB.n7 VSS 0.026533f
C32 IB.n8 VSS 0.032134f
C33 IB.t40 VSS 0.012262f
C34 IB.t41 VSS 0.012262f
C35 IB.n9 VSS 0.026533f
C36 IB.n10 VSS 0.032134f
C37 IB.t56 VSS 0.012262f
C38 IB.t52 VSS 0.012262f
C39 IB.n11 VSS 0.026533f
C40 IB.n12 VSS 0.032134f
C41 IB.t32 VSS 0.012262f
C42 IB.t0 VSS 0.012262f
C43 IB.n13 VSS 0.026533f
C44 IB.n14 VSS 0.032134f
C45 IB.t14 VSS 0.012262f
C46 IB.t24 VSS 0.012262f
C47 IB.n15 VSS 0.026533f
C48 IB.n16 VSS 0.032134f
C49 IB.t50 VSS 0.012262f
C50 IB.t49 VSS 0.012262f
C51 IB.n17 VSS 0.026533f
C52 IB.n18 VSS 0.032134f
C53 IB.t45 VSS 0.012262f
C54 IB.t58 VSS 0.012262f
C55 IB.n19 VSS 0.026533f
C56 IB.t2 VSS 0.012262f
C57 IB.t4 VSS 0.012262f
C58 IB.n20 VSS 0.026597f
C59 IB.t51 VSS 0.012262f
C60 IB.t44 VSS 0.012262f
C61 IB.n21 VSS 0.026533f
C62 IB.n22 VSS 0.059316f
C63 IB.t59 VSS 0.012262f
C64 IB.t55 VSS 0.012262f
C65 IB.n23 VSS 0.026533f
C66 IB.n24 VSS 0.032134f
C67 IB.t22 VSS 0.012262f
C68 IB.t30 VSS 0.012262f
C69 IB.n25 VSS 0.026533f
C70 IB.n26 VSS 0.032134f
C71 IB.t12 VSS 0.012262f
C72 IB.t20 VSS 0.012262f
C73 IB.n27 VSS 0.026533f
C74 IB.n28 VSS 0.032134f
C75 IB.t48 VSS 0.012262f
C76 IB.t43 VSS 0.012262f
C77 IB.n29 VSS 0.026533f
C78 IB.n30 VSS 0.032134f
C79 IB.t57 VSS 0.012262f
C80 IB.t54 VSS 0.012262f
C81 IB.n31 VSS 0.026533f
C82 IB.n32 VSS 0.032134f
C83 IB.t36 VSS 0.012262f
C84 IB.t34 VSS 0.012262f
C85 IB.n33 VSS 0.026533f
C86 IB.n34 VSS 0.032134f
C87 IB.t16 VSS 0.012262f
C88 IB.t26 VSS 0.012262f
C89 IB.n35 VSS 0.026533f
C90 IB.n36 VSS 0.032134f
C91 IB.n37 VSS 0.036054f
C92 IB.t39 VSS 0.00888f
C93 IB.t7 VSS 0.00888f
C94 IB.n38 VSS 0.049504f
C95 IB.t9 VSS 0.00888f
C96 IB.t11 VSS 0.00888f
C97 IB.n39 VSS 0.049089f
C98 IB.n40 VSS 0.115161f
C99 IB.t19 VSS 0.00888f
C100 IB.t29 VSS 0.00888f
C101 IB.n41 VSS 0.049089f
C102 IB.n42 VSS 0.060231f
C103 IB.t33 VSS 0.00888f
C104 IB.t1 VSS 0.00888f
C105 IB.n43 VSS 0.049089f
C106 IB.n44 VSS 0.060231f
C107 IB.t15 VSS 0.00888f
C108 IB.t25 VSS 0.00888f
C109 IB.n45 VSS 0.049089f
C110 IB.n46 VSS 0.05215f
C111 IB.t3 VSS 0.00888f
C112 IB.t5 VSS 0.00888f
C113 IB.n47 VSS 0.049504f
C114 IB.t23 VSS 0.00888f
C115 IB.t31 VSS 0.00888f
C116 IB.n48 VSS 0.049089f
C117 IB.n49 VSS 0.115161f
C118 IB.t13 VSS 0.00888f
C119 IB.t21 VSS 0.00888f
C120 IB.n50 VSS 0.049089f
C121 IB.n51 VSS 0.060231f
C122 IB.t37 VSS 0.00888f
C123 IB.t35 VSS 0.00888f
C124 IB.n52 VSS 0.049089f
C125 IB.n53 VSS 0.060231f
C126 IB.t17 VSS 0.00888f
C127 IB.t27 VSS 0.00888f
C128 IB.n54 VSS 0.049089f
C129 IB.n55 VSS 0.044068f
C130 IB.n56 VSS 0.028165f
C131 VDD.n0 VSS 2.56946f
C132 VDD.n1 VSS 0.299648f
C133 VDD.n2 VSS 0.299648f
C134 VDD.n3 VSS 0.224736f
C135 VDD.n4 VSS 0.141434f
C136 VDD.n5 VSS 0.224736f
C137 VDD.n6 VSS 0.224736f
C138 VDD.n7 VSS 0.703289f
C139 VDD.n8 VSS 0.06039f
C140 VDD.n9 VSS 0.128979f
C141 VDD.n10 VSS 6.32586f
C142 li_1695_571.t9 VSS 0.051733f
C143 li_1695_571.t5 VSS 0.051733f
C144 li_1695_571.t3 VSS 0.051733f
C145 li_1695_571.n0 VSS 0.214846f
C146 li_1695_571.t19 VSS 0.051733f
C147 li_1695_571.t15 VSS 0.051733f
C148 li_1695_571.n1 VSS 0.214393f
C149 li_1695_571.n2 VSS 0.627717f
C150 li_1695_571.t4 VSS 0.071434f
C151 li_1695_571.t2 VSS 0.071434f
C152 li_1695_571.n3 VSS 0.154951f
C153 li_1695_571.t18 VSS 0.071434f
C154 li_1695_571.t14 VSS 0.070826f
C155 li_1695_571.n4 VSS 0.058508f
C156 li_1695_571.n5 VSS 0.062819f
C157 li_1695_571.n6 VSS 0.087524f
C158 li_1695_571.n7 VSS 0.345562f
C159 li_1695_571.t8 VSS 0.070826f
C160 li_1695_571.n8 VSS 0.058508f
C161 li_1695_571.n9 VSS 0.062819f
C162 li_1695_571.t0 VSS 0.070826f
C163 li_1695_571.n10 VSS 0.058508f
C164 li_1695_571.n11 VSS 0.062819f
C165 li_1695_571.n12 VSS 0.020474f
C166 li_1695_571.t10 VSS 0.106473f
C167 li_1695_571.t6 VSS 0.106473f
C168 li_1695_571.n13 VSS 0.19221f
C169 li_1695_571.t16 VSS 0.070826f
C170 li_1695_571.n14 VSS 0.058508f
C171 li_1695_571.n15 VSS 0.062819f
C172 li_1695_571.t12 VSS 0.106473f
C173 li_1695_571.n16 VSS 0.106153f
C174 li_1695_571.n17 VSS 0.345562f
C175 li_1695_571.n18 VSS 0.188823f
C176 li_1695_571.t26 VSS 0.071434f
C177 li_1695_571.t24 VSS 0.071434f
C178 li_1695_571.n19 VSS 0.154951f
C179 li_1695_571.t23 VSS 0.071434f
C180 li_1695_571.t21 VSS 0.071434f
C181 li_1695_571.n20 VSS 0.154574f
C182 li_1695_571.n21 VSS 0.345562f
C183 li_1695_571.t29 VSS 0.071434f
C184 li_1695_571.t25 VSS 0.071434f
C185 li_1695_571.n22 VSS 0.154574f
C186 li_1695_571.n23 VSS 0.187203f
C187 li_1695_571.t22 VSS 0.071434f
C188 li_1695_571.t20 VSS 0.071434f
C189 li_1695_571.n24 VSS 0.154574f
C190 li_1695_571.n25 VSS 0.187203f
C191 li_1695_571.t28 VSS 0.071434f
C192 li_1695_571.t27 VSS 0.071434f
C193 li_1695_571.n26 VSS 0.154574f
C194 li_1695_571.n27 VSS 0.411836f
C195 li_1695_571.n28 VSS 4.05868f
C196 li_1695_571.t11 VSS 0.051733f
C197 li_1695_571.t7 VSS 0.051733f
C198 li_1695_571.n29 VSS 0.214846f
C199 li_1695_571.t17 VSS 0.051733f
C200 li_1695_571.t13 VSS 0.051733f
C201 li_1695_571.n30 VSS 0.214393f
C202 li_1695_571.n31 VSS 0.627717f
C203 li_1695_571.n32 VSS 1.6327f
C204 li_1695_571.n33 VSS 0.214393f
C205 li_1695_571.t1 VSS 0.051733f
C206 VIP VSS 2.746794f
C207 VOUT VSS 9.349874f
C208 m1_1634_1652# VSS 11.364938f
C209 VIN VSS 2.733077f
C210 IB VSS 16.885843f
C211 VDD VSS 16.218754f
.ends
