* NGSPICE file created from FIVE_TRANSISTOR_OTA_0.ext - technology: sky130A

.subckt DCL_PMOS_S_9664157_X5_Y1_1774869020 a_200_252# w_0_0#
X0 a_200_252# a_200_252# w_0_0# w_0_0# sky130_fd_pr__pfet_01v8 ad=0.2646 pd=2.17 as=0.2646 ps=2.17 w=1.89 l=0.15 M=10
.ends

.subckt PMOS_S_72158034_X5_Y1_1774869022 a_200_252# a_230_378# w_0_0#
X0 a_230_378# a_200_252# w_0_0# w_0_0# sky130_fd_pr__pfet_01v8 ad=0.2646 pd=2.17 as=0.2646 ps=2.17 w=1.89 l=0.15 M=10
.ends

.subckt SCM_NMOS_26075846_X10_Y1_1774869023 a_200_252# a_402_378# a_147_378#
X0 a_147_378# a_200_252# a_402_378# a_147_378# sky130_fd_pr__nfet_01v8 ad=0.2646 pd=2.17 as=0.2646 ps=2.17 w=1.89 l=0.15 M=20
X1 a_147_378# a_200_252# a_200_252# a_147_378# sky130_fd_pr__nfet_01v8 ad=0.50085 pd=4.31 as=0.2646 ps=2.17 w=1.89 l=0.15 M=20
.ends

.subckt NMOS_4T_39571376_X7_Y1_1774869021 a_200_252# a_230_378# a_147_378# a_241_1232#
X0 a_230_378# a_200_252# a_147_378# a_241_1232# sky130_fd_pr__nfet_01v8 ad=0.2646 pd=2.17 as=0.2646 ps=2.17 w=1.89 l=0.15 M=14
.ends

.subckt FIVE_TRANSISTOR_OTA_0 IB VOUT VIP VIN VSS VDD
XDCL_PMOS_S_9664157_X5_Y1_1774869020_0 li_1695_571# VDD DCL_PMOS_S_9664157_X5_Y1_1774869020
XPMOS_S_72158034_X5_Y1_1774869022_0 li_1695_571# VOUT VDD PMOS_S_72158034_X5_Y1_1774869022
XSCM_NMOS_26075846_X10_Y1_1774869023_0 IB m1_1634_1652# VSS SCM_NMOS_26075846_X10_Y1_1774869023
XNMOS_4T_39571376_X7_Y1_1774869021_0 VIN VOUT m1_1634_1652# VSS NMOS_4T_39571376_X7_Y1_1774869021
XNMOS_4T_39571376_X7_Y1_1774869021_1 VIP li_1695_571# m1_1634_1652# VSS NMOS_4T_39571376_X7_Y1_1774869021
.ends
