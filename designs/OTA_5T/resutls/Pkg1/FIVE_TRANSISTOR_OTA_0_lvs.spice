* NGSPICE file created from FIVE_TRANSISTOR_OTA_0.ext - technology: sky130A

.subckt DCL_PMOS_S_78259359_X5_Y1_1774868955 a_200_252# w_0_0#
X0 a_200_252# a_200_252# w_0_0# w_0_0# sky130_fd_pr__pfet_01v8 ad=0.294 pd=2.38 as=0.5565 ps=4.73 w=2.1 l=0.15 M=10
.ends

.subckt NMOS_4T_1818045_X5_Y2_1774868956 a_230_357# a_200_252# a_147_357# a_241_2408#
X0 a_230_357# a_200_252# a_147_357# a_241_2408# sky130_fd_pr__nfet_01v8 ad=0.294 pd=2.38 as=0.294 ps=2.38 w=2.1 l=0.15 M=20
.ends

.subckt PMOS_S_49267959_X5_Y1_1774868957 a_230_357# a_200_252# w_0_0#
X0 a_230_357# a_200_252# w_0_0# w_0_0# sky130_fd_pr__pfet_01v8 ad=0.294 pd=2.38 as=0.5565 ps=4.73 w=2.1 l=0.15 M=10
.ends

.subckt SCM_NMOS_72619132_X7_Y1_1774868958 a_200_252# a_402_357# a_147_357#
X0 a_200_252# a_200_252# a_147_357# a_147_357# sky130_fd_pr__nfet_01v8 ad=0.294 pd=2.38 as=0.294 ps=2.38 w=2.1 l=0.15 M=14
X1 a_147_357# a_200_252# a_402_357# a_147_357# sky130_fd_pr__nfet_01v8 ad=0.294 pd=2.38 as=0.294 ps=2.38 w=2.1 l=0.15 M=14
.ends

.subckt FIVE_TRANSISTOR_OTA_0 IB VOUT VIP VIN VSS VDD
XDCL_PMOS_S_78259359_X5_Y1_1774868955_0 m2_574_4247# VDD DCL_PMOS_S_78259359_X5_Y1_1774868955
XNMOS_4T_1818045_X5_Y2_1774868956_0 VOUT VIN m1_484_2996# VSS NMOS_4T_1818045_X5_Y2_1774868956
XNMOS_4T_1818045_X5_Y2_1774868956_1 m2_574_4247# VIP m1_484_2996# VSS NMOS_4T_1818045_X5_Y2_1774868956
XPMOS_S_49267959_X5_Y1_1774868957_0 VOUT m2_574_4247# VDD PMOS_S_49267959_X5_Y1_1774868957
XSCM_NMOS_72619132_X7_Y1_1774868958_0 IB m1_484_2996# VSS SCM_NMOS_72619132_X7_Y1_1774868958
.ends
