* NGSPICE file created from FIVE_TRANSISTOR_OTA_0.ext - technology: sky130A

.subckt DCL_PMOS_S_78259359_X5_Y1_1774868955 a_200_252# w_0_0# VSUBS
X0 a_200_252# a_200_252# w_0_0# w_0_0# sky130_fd_pr__pfet_01v8 ad=0.294 pd=2.38 as=0.5565 ps=4.73 w=2.1 l=0.15
X1 w_0_0# a_200_252# a_200_252# w_0_0# sky130_fd_pr__pfet_01v8 ad=0.294 pd=2.38 as=0.294 ps=2.38 w=2.1 l=0.15
X2 w_0_0# a_200_252# a_200_252# w_0_0# sky130_fd_pr__pfet_01v8 ad=0.294 pd=2.38 as=0.294 ps=2.38 w=2.1 l=0.15
X3 a_200_252# a_200_252# w_0_0# w_0_0# sky130_fd_pr__pfet_01v8 ad=0.294 pd=2.38 as=0.294 ps=2.38 w=2.1 l=0.15
X4 a_200_252# a_200_252# w_0_0# w_0_0# sky130_fd_pr__pfet_01v8 ad=0.294 pd=2.38 as=0.294 ps=2.38 w=2.1 l=0.15
X5 w_0_0# a_200_252# a_200_252# w_0_0# sky130_fd_pr__pfet_01v8 ad=0.294 pd=2.38 as=0.294 ps=2.38 w=2.1 l=0.15
X6 w_0_0# a_200_252# a_200_252# w_0_0# sky130_fd_pr__pfet_01v8 ad=0.294 pd=2.38 as=0.294 ps=2.38 w=2.1 l=0.15
X7 a_200_252# a_200_252# w_0_0# w_0_0# sky130_fd_pr__pfet_01v8 ad=0.294 pd=2.38 as=0.294 ps=2.38 w=2.1 l=0.15
X8 a_200_252# a_200_252# w_0_0# w_0_0# sky130_fd_pr__pfet_01v8 ad=0.294 pd=2.38 as=0.294 ps=2.38 w=2.1 l=0.15
X9 w_0_0# a_200_252# a_200_252# w_0_0# sky130_fd_pr__pfet_01v8 ad=0.5565 pd=4.73 as=0.294 ps=2.38 w=2.1 l=0.15
C0 w_0_0# a_200_252# 6.15257f
C1 a_200_252# VSUBS 0.586891f
C2 w_0_0# VSUBS 5.8424f
.ends

.subckt NMOS_4T_1818045_X5_Y2_1774868956 a_230_357# a_200_252# a_147_357# a_241_2408#
X0 a_230_357# a_200_252# a_147_357# a_241_2408# sky130_fd_pr__nfet_01v8 ad=0.294 pd=2.38 as=0.294 ps=2.38 w=2.1 l=0.15
X1 a_147_357# a_200_252# a_230_357# a_241_2408# sky130_fd_pr__nfet_01v8 ad=0.5565 pd=4.73 as=0.294 ps=2.38 w=2.1 l=0.15
X2 a_230_357# a_200_252# a_147_357# a_241_2408# sky130_fd_pr__nfet_01v8 ad=0.294 pd=2.38 as=0.5565 ps=4.73 w=2.1 l=0.15
X3 a_147_357# a_200_252# a_230_357# a_241_2408# sky130_fd_pr__nfet_01v8 ad=0.294 pd=2.38 as=0.294 ps=2.38 w=2.1 l=0.15
X4 a_147_357# a_200_252# a_230_357# a_241_2408# sky130_fd_pr__nfet_01v8 ad=0.294 pd=2.38 as=0.294 ps=2.38 w=2.1 l=0.15
X5 a_230_357# a_200_252# a_147_357# a_241_2408# sky130_fd_pr__nfet_01v8 ad=0.294 pd=2.38 as=0.294 ps=2.38 w=2.1 l=0.15
X6 a_230_357# a_200_252# a_147_357# a_241_2408# sky130_fd_pr__nfet_01v8 ad=0.294 pd=2.38 as=0.294 ps=2.38 w=2.1 l=0.15
X7 a_147_357# a_200_252# a_230_357# a_241_2408# sky130_fd_pr__nfet_01v8 ad=0.294 pd=2.38 as=0.294 ps=2.38 w=2.1 l=0.15
X8 a_230_357# a_200_252# a_147_357# a_241_2408# sky130_fd_pr__nfet_01v8 ad=0.294 pd=2.38 as=0.294 ps=2.38 w=2.1 l=0.15
X9 a_230_357# a_200_252# a_147_357# a_241_2408# sky130_fd_pr__nfet_01v8 ad=0.294 pd=2.38 as=0.5565 ps=4.73 w=2.1 l=0.15
X10 a_147_357# a_200_252# a_230_357# a_241_2408# sky130_fd_pr__nfet_01v8 ad=0.294 pd=2.38 as=0.294 ps=2.38 w=2.1 l=0.15
X11 a_230_357# a_200_252# a_147_357# a_241_2408# sky130_fd_pr__nfet_01v8 ad=0.294 pd=2.38 as=0.294 ps=2.38 w=2.1 l=0.15
X12 a_147_357# a_200_252# a_230_357# a_241_2408# sky130_fd_pr__nfet_01v8 ad=0.294 pd=2.38 as=0.294 ps=2.38 w=2.1 l=0.15
X13 a_147_357# a_200_252# a_230_357# a_241_2408# sky130_fd_pr__nfet_01v8 ad=0.294 pd=2.38 as=0.294 ps=2.38 w=2.1 l=0.15
X14 a_230_357# a_200_252# a_147_357# a_241_2408# sky130_fd_pr__nfet_01v8 ad=0.294 pd=2.38 as=0.294 ps=2.38 w=2.1 l=0.15
X15 a_147_357# a_200_252# a_230_357# a_241_2408# sky130_fd_pr__nfet_01v8 ad=0.294 pd=2.38 as=0.294 ps=2.38 w=2.1 l=0.15
X16 a_230_357# a_200_252# a_147_357# a_241_2408# sky130_fd_pr__nfet_01v8 ad=0.294 pd=2.38 as=0.294 ps=2.38 w=2.1 l=0.15
X17 a_230_357# a_200_252# a_147_357# a_241_2408# sky130_fd_pr__nfet_01v8 ad=0.294 pd=2.38 as=0.294 ps=2.38 w=2.1 l=0.15
X18 a_147_357# a_200_252# a_230_357# a_241_2408# sky130_fd_pr__nfet_01v8 ad=0.294 pd=2.38 as=0.294 ps=2.38 w=2.1 l=0.15
X19 a_147_357# a_200_252# a_230_357# a_241_2408# sky130_fd_pr__nfet_01v8 ad=0.5565 pd=4.73 as=0.294 ps=2.38 w=2.1 l=0.15
C0 a_147_357# a_230_357# 7.38041f
C1 a_200_252# a_147_357# 1.26641f
C2 a_200_252# a_230_357# 1.36378f
C3 a_230_357# a_241_2408# 0.770657f
C4 a_147_357# a_241_2408# 1.32775f
C5 a_200_252# a_241_2408# 3.56016f
.ends

.subckt PMOS_S_49267959_X5_Y1_1774868957 a_230_357# a_200_252# w_0_0# VSUBS
X0 a_230_357# a_200_252# w_0_0# w_0_0# sky130_fd_pr__pfet_01v8 ad=0.294 pd=2.38 as=0.5565 ps=4.73 w=2.1 l=0.15
X1 w_0_0# a_200_252# a_230_357# w_0_0# sky130_fd_pr__pfet_01v8 ad=0.294 pd=2.38 as=0.294 ps=2.38 w=2.1 l=0.15
X2 w_0_0# a_200_252# a_230_357# w_0_0# sky130_fd_pr__pfet_01v8 ad=0.294 pd=2.38 as=0.294 ps=2.38 w=2.1 l=0.15
X3 a_230_357# a_200_252# w_0_0# w_0_0# sky130_fd_pr__pfet_01v8 ad=0.294 pd=2.38 as=0.294 ps=2.38 w=2.1 l=0.15
X4 a_230_357# a_200_252# w_0_0# w_0_0# sky130_fd_pr__pfet_01v8 ad=0.294 pd=2.38 as=0.294 ps=2.38 w=2.1 l=0.15
X5 w_0_0# a_200_252# a_230_357# w_0_0# sky130_fd_pr__pfet_01v8 ad=0.294 pd=2.38 as=0.294 ps=2.38 w=2.1 l=0.15
X6 w_0_0# a_200_252# a_230_357# w_0_0# sky130_fd_pr__pfet_01v8 ad=0.294 pd=2.38 as=0.294 ps=2.38 w=2.1 l=0.15
X7 a_230_357# a_200_252# w_0_0# w_0_0# sky130_fd_pr__pfet_01v8 ad=0.294 pd=2.38 as=0.294 ps=2.38 w=2.1 l=0.15
X8 a_230_357# a_200_252# w_0_0# w_0_0# sky130_fd_pr__pfet_01v8 ad=0.294 pd=2.38 as=0.294 ps=2.38 w=2.1 l=0.15
X9 w_0_0# a_200_252# a_230_357# w_0_0# sky130_fd_pr__pfet_01v8 ad=0.5565 pd=4.73 as=0.294 ps=2.38 w=2.1 l=0.15
C0 a_200_252# a_230_357# 0.394203f
C1 w_0_0# a_200_252# 1.96638f
C2 w_0_0# a_230_357# 3.68178f
C3 a_230_357# VSUBS 0.20286f
C4 a_200_252# VSUBS 0.310193f
C5 w_0_0# VSUBS 5.84222f
.ends

.subckt SCM_NMOS_72619132_X7_Y1_1774868958 a_200_252# a_402_357# a_147_357#
X0 a_200_252# a_200_252# a_147_357# a_147_357# sky130_fd_pr__nfet_01v8 ad=0.294 pd=2.38 as=0.294 ps=2.38 w=2.1 l=0.15
X1 a_147_357# a_200_252# a_402_357# a_147_357# sky130_fd_pr__nfet_01v8 ad=0.294 pd=2.38 as=0.294 ps=2.38 w=2.1 l=0.15
X2 a_147_357# a_200_252# a_402_357# a_147_357# sky130_fd_pr__nfet_01v8 ad=0.5565 pd=4.73 as=0.294 ps=2.38 w=2.1 l=0.15
X3 a_147_357# a_200_252# a_200_252# a_147_357# sky130_fd_pr__nfet_01v8 ad=0.294 pd=2.38 as=0.294 ps=2.38 w=2.1 l=0.15
X4 a_147_357# a_200_252# a_200_252# a_147_357# sky130_fd_pr__nfet_01v8 ad=0.294 pd=2.38 as=0.294 ps=2.38 w=2.1 l=0.15
X5 a_200_252# a_200_252# a_147_357# a_147_357# sky130_fd_pr__nfet_01v8 ad=0.294 pd=2.38 as=0.5565 ps=4.73 w=2.1 l=0.15
X6 a_147_357# a_200_252# a_200_252# a_147_357# sky130_fd_pr__nfet_01v8 ad=0.294 pd=2.38 as=0.294 ps=2.38 w=2.1 l=0.15
X7 a_402_357# a_200_252# a_147_357# a_147_357# sky130_fd_pr__nfet_01v8 ad=0.294 pd=2.38 as=0.294 ps=2.38 w=2.1 l=0.15
X8 a_147_357# a_200_252# a_200_252# a_147_357# sky130_fd_pr__nfet_01v8 ad=0.294 pd=2.38 as=0.294 ps=2.38 w=2.1 l=0.15
X9 a_200_252# a_200_252# a_147_357# a_147_357# sky130_fd_pr__nfet_01v8 ad=0.294 pd=2.38 as=0.294 ps=2.38 w=2.1 l=0.15
X10 a_402_357# a_200_252# a_147_357# a_147_357# sky130_fd_pr__nfet_01v8 ad=0.294 pd=2.38 as=0.294 ps=2.38 w=2.1 l=0.15
X11 a_402_357# a_200_252# a_147_357# a_147_357# sky130_fd_pr__nfet_01v8 ad=0.294 pd=2.38 as=0.294 ps=2.38 w=2.1 l=0.15
X12 a_147_357# a_200_252# a_402_357# a_147_357# sky130_fd_pr__nfet_01v8 ad=0.294 pd=2.38 as=0.294 ps=2.38 w=2.1 l=0.15
X13 a_402_357# a_200_252# a_147_357# a_147_357# sky130_fd_pr__nfet_01v8 ad=0.294 pd=2.38 as=0.294 ps=2.38 w=2.1 l=0.15
X14 a_147_357# a_200_252# a_402_357# a_147_357# sky130_fd_pr__nfet_01v8 ad=0.294 pd=2.38 as=0.294 ps=2.38 w=2.1 l=0.15
X15 a_147_357# a_200_252# a_200_252# a_147_357# sky130_fd_pr__nfet_01v8 ad=0.294 pd=2.38 as=0.294 ps=2.38 w=2.1 l=0.15
X16 a_402_357# a_200_252# a_147_357# a_147_357# sky130_fd_pr__nfet_01v8 ad=0.294 pd=2.38 as=0.294 ps=2.38 w=2.1 l=0.15
X17 a_147_357# a_200_252# a_402_357# a_147_357# sky130_fd_pr__nfet_01v8 ad=0.294 pd=2.38 as=0.294 ps=2.38 w=2.1 l=0.15
X18 a_200_252# a_200_252# a_147_357# a_147_357# sky130_fd_pr__nfet_01v8 ad=0.294 pd=2.38 as=0.294 ps=2.38 w=2.1 l=0.15
X19 a_200_252# a_200_252# a_147_357# a_147_357# sky130_fd_pr__nfet_01v8 ad=0.294 pd=2.38 as=0.294 ps=2.38 w=2.1 l=0.15
X20 a_147_357# a_200_252# a_200_252# a_147_357# sky130_fd_pr__nfet_01v8 ad=0.294 pd=2.38 as=0.294 ps=2.38 w=2.1 l=0.15
X21 a_402_357# a_200_252# a_147_357# a_147_357# sky130_fd_pr__nfet_01v8 ad=0.294 pd=2.38 as=0.294 ps=2.38 w=2.1 l=0.15
X22 a_147_357# a_200_252# a_402_357# a_147_357# sky130_fd_pr__nfet_01v8 ad=0.294 pd=2.38 as=0.294 ps=2.38 w=2.1 l=0.15
X23 a_402_357# a_200_252# a_147_357# a_147_357# sky130_fd_pr__nfet_01v8 ad=0.294 pd=2.38 as=0.294 ps=2.38 w=2.1 l=0.15
X24 a_147_357# a_200_252# a_402_357# a_147_357# sky130_fd_pr__nfet_01v8 ad=0.294 pd=2.38 as=0.294 ps=2.38 w=2.1 l=0.15
X25 a_200_252# a_200_252# a_147_357# a_147_357# sky130_fd_pr__nfet_01v8 ad=0.294 pd=2.38 as=0.294 ps=2.38 w=2.1 l=0.15
X26 a_200_252# a_200_252# a_147_357# a_147_357# sky130_fd_pr__nfet_01v8 ad=0.294 pd=2.38 as=0.294 ps=2.38 w=2.1 l=0.15
X27 a_147_357# a_200_252# a_200_252# a_147_357# sky130_fd_pr__nfet_01v8 ad=0.294 pd=2.38 as=0.294 ps=2.38 w=2.1 l=0.15
C0 a_200_252# a_402_357# 1.93269f
C1 a_402_357# a_147_357# 5.97736f
C2 a_200_252# a_147_357# 11.444099f
.ends

.subckt FIVE_TRANSISTOR_OTA_0 IB VOUT VIP VIN VSS VDD
XDCL_PMOS_S_78259359_X5_Y1_1774868955_0 m2_574_4247# VDD VSS DCL_PMOS_S_78259359_X5_Y1_1774868955
XNMOS_4T_1818045_X5_Y2_1774868956_0 VOUT VIN m1_484_2996# VSS NMOS_4T_1818045_X5_Y2_1774868956
XNMOS_4T_1818045_X5_Y2_1774868956_1 m2_574_4247# VIP m1_484_2996# VSS NMOS_4T_1818045_X5_Y2_1774868956
XPMOS_S_49267959_X5_Y1_1774868957_0 VOUT m2_574_4247# VDD VSS PMOS_S_49267959_X5_Y1_1774868957
XSCM_NMOS_72619132_X7_Y1_1774868958_0 IB m1_484_2996# VSS SCM_NMOS_72619132_X7_Y1_1774868958
R0 m2_574_4247.n4 m2_574_4247.t0 568.582
R1 m2_574_4247.n4 m2_574_4247.t4 568.582
R2 m2_574_4247.n5 m2_574_4247.t6 568.582
R3 m2_574_4247.n5 m2_574_4247.t10 568.582
R4 m2_574_4247.n3 m2_574_4247.t14 568.582
R5 m2_574_4247.n3 m2_574_4247.t2 568.582
R6 m2_574_4247.n1 m2_574_4247.t8 568.582
R7 m2_574_4247.n1 m2_574_4247.t12 568.582
R8 m2_574_4247.n0 m2_574_4247.t16 568.582
R9 m2_574_4247.n0 m2_574_4247.t18 568.582
R10 m2_574_4247.n15 m2_574_4247.t20 568.582
R11 m2_574_4247.n15 m2_574_4247.t21 568.582
R12 m2_574_4247.n13 m2_574_4247.t23 568.582
R13 m2_574_4247.n13 m2_574_4247.t25 568.582
R14 m2_574_4247.n11 m2_574_4247.t28 568.582
R15 m2_574_4247.n11 m2_574_4247.t22 568.582
R16 m2_574_4247.n9 m2_574_4247.t24 568.582
R17 m2_574_4247.n9 m2_574_4247.t26 568.582
R18 m2_574_4247.n8 m2_574_4247.t27 568.582
R19 m2_574_4247.n8 m2_574_4247.t29 568.582
R20 m2_574_4247.n20 m2_574_4247.n18 224.639
R21 m2_574_4247.n25 m2_574_4247.n24 224.637
R22 m2_574_4247.n20 m2_574_4247.n19 224.256
R23 m2_574_4247.n22 m2_574_4247.n21 224.256
R24 m2_574_4247.n24 m2_574_4247.n23 224.256
R25 m2_574_4247.n6 m2_574_4247.n4 161.685
R26 m2_574_4247.n2 m2_574_4247.n0 161.685
R27 m2_574_4247.n10 m2_574_4247.n8 161.685
R28 m2_574_4247.n6 m2_574_4247.n5 161.3
R29 m2_574_4247.n7 m2_574_4247.n3 161.3
R30 m2_574_4247.n2 m2_574_4247.n1 161.3
R31 m2_574_4247.n16 m2_574_4247.n15 161.3
R32 m2_574_4247.n14 m2_574_4247.n13 161.3
R33 m2_574_4247.n12 m2_574_4247.n11 161.3
R34 m2_574_4247.n10 m2_574_4247.n9 161.3
R35 m2_574_4247.n17 m2_574_4247.n16 46.5241
R36 m2_574_4247.n18 m2_574_4247.t5 13.1338
R37 m2_574_4247.n18 m2_574_4247.t1 13.1338
R38 m2_574_4247.n19 m2_574_4247.t11 13.1338
R39 m2_574_4247.n19 m2_574_4247.t7 13.1338
R40 m2_574_4247.n21 m2_574_4247.t3 13.1338
R41 m2_574_4247.n21 m2_574_4247.t15 13.1338
R42 m2_574_4247.n23 m2_574_4247.t13 13.1338
R43 m2_574_4247.n23 m2_574_4247.t9 13.1338
R44 m2_574_4247.t19 m2_574_4247.n25 13.1338
R45 m2_574_4247.n25 m2_574_4247.t17 13.1338
R46 m2_574_4247.n22 m2_574_4247.n17 6.188
R47 m2_574_4247.n17 m2_574_4247.n7 4.688
R48 m2_574_4247.n7 m2_574_4247.n2 0.384429
R49 m2_574_4247.n7 m2_574_4247.n6 0.384429
R50 m2_574_4247.n12 m2_574_4247.n10 0.384429
R51 m2_574_4247.n14 m2_574_4247.n12 0.384429
R52 m2_574_4247.n16 m2_574_4247.n14 0.384429
R53 m2_574_4247.n24 m2_574_4247.n22 0.384429
R54 m2_574_4247.n22 m2_574_4247.n20 0.384429
R55 VIN.n4 VIN.t3 568.582
R56 VIN.n4 VIN.t2 568.582
R57 VIN.n5 VIN.t13 568.582
R58 VIN.n5 VIN.t5 568.582
R59 VIN.n3 VIN.t4 568.582
R60 VIN.n3 VIN.t0 568.582
R61 VIN.n1 VIN.t15 568.582
R62 VIN.n1 VIN.t6 568.582
R63 VIN.n0 VIN.t1 568.582
R64 VIN.n0 VIN.t16 568.582
R65 VIN.n12 VIN.t12 568.582
R66 VIN.n12 VIN.t9 568.582
R67 VIN.n13 VIN.t7 568.582
R68 VIN.n13 VIN.t17 568.582
R69 VIN.n11 VIN.t18 568.582
R70 VIN.n11 VIN.t11 568.582
R71 VIN.n9 VIN.t10 568.582
R72 VIN.n9 VIN.t8 568.582
R73 VIN.n8 VIN.t19 568.582
R74 VIN.n8 VIN.t14 568.582
R75 VIN.n6 VIN.n4 161.685
R76 VIN.n2 VIN.n0 161.685
R77 VIN.n14 VIN.n12 161.685
R78 VIN.n10 VIN.n8 161.685
R79 VIN.n6 VIN.n5 161.3
R80 VIN.n7 VIN.n3 161.3
R81 VIN.n2 VIN.n1 161.3
R82 VIN.n14 VIN.n13 161.3
R83 VIN.n15 VIN.n11 161.3
R84 VIN.n10 VIN.n9 161.3
R85 VIN VIN.n7 5.813
R86 VIN VIN.n15 5.813
R87 VIN.n7 VIN.n2 0.384429
R88 VIN.n7 VIN.n6 0.384429
R89 VIN.n15 VIN.n10 0.384429
R90 VIN.n15 VIN.n14 0.384429
R91 VSS.n108 VSS.n107 1179.68
R92 VSS.n15 VSS.n9 1179.68
R93 VSS.n97 VSS.n93 1179.68
R94 VSS.n20 VSS.n5 1179.68
R95 VSS.n118 VSS.n117 1179.49
R96 VSS.n15 VSS.n14 1179.3
R97 VSS.n16 VSS.n5 1179.3
R98 VSS.n19 VSS.n17 1179.3
R99 VSS.n22 VSS.n3 1179.3
R100 VSS.n27 VSS.n26 1179.3
R101 VSS.n117 VSS.n84 1179.3
R102 VSS.n114 VSS.n113 1179.3
R103 VSS.n112 VSS.n111 1179.3
R104 VSS.n108 VSS.n86 1179.3
R105 VSS.n106 VSS.n91 1179.3
R106 VSS.n103 VSS.n92 1179.3
R107 VSS.n100 VSS.n93 1179.3
R108 VSS.n107 VSS.n106 1179.3
R109 VSS.n103 VSS.n89 1179.3
R110 VSS.n100 VSS.n99 1179.3
R111 VSS.n98 VSS.n97 1179.3
R112 VSS.n20 VSS.n19 1179.3
R113 VSS.n22 VSS.n21 1179.3
R114 VSS.n26 VSS.n1 1179.3
R115 VSS.n57 VSS.n53 840.539
R116 VSS.n32 VSS.n28 840.539
R117 VSS.n57 VSS.n56 99.0144
R118 VSS.n61 VSS.n60 99.0144
R119 VSS.n65 VSS.n64 99.0144
R120 VSS.n69 VSS.n68 99.0144
R121 VSS.n73 VSS.n72 99.0144
R122 VSS.n77 VSS.n76 99.0144
R123 VSS.n81 VSS.n80 99.0144
R124 VSS.n52 VSS.n51 99.0144
R125 VSS.n48 VSS.n47 99.0144
R126 VSS.n44 VSS.n43 99.0144
R127 VSS.n40 VSS.n39 99.0144
R128 VSS.n36 VSS.n35 99.0144
R129 VSS.n32 VSS.n31 99.0144
R130 VSS.n11 VSS.n10 87.6337
R131 VSS.n13 VSS.n12 87.6337
R132 VSS.n7 VSS.n6 87.6337
R133 VSS.n18 VSS.n4 87.6337
R134 VSS.n24 VSS.n23 87.6337
R135 VSS.n25 VSS.n2 87.6337
R136 VSS.n116 VSS.n115 87.6337
R137 VSS.n87 VSS.n85 87.6337
R138 VSS.n110 VSS.n109 87.6337
R139 VSS.n90 VSS.n88 87.6337
R140 VSS.n105 VSS.n104 87.6337
R141 VSS.n102 VSS.n101 87.6337
R142 VSS.n95 VSS.n94 87.6337
R143 VSS.n9 VSS.n8 43.8171
R144 VSS.n10 VSS.n9 43.8171
R145 VSS.n14 VSS.n11 43.8171
R146 VSS.n14 VSS.n13 43.8171
R147 VSS.n12 VSS.n5 43.8171
R148 VSS.n6 VSS.n5 43.8171
R149 VSS.n19 VSS.n7 43.8171
R150 VSS.n19 VSS.n18 43.8171
R151 VSS.n22 VSS.n4 43.8171
R152 VSS.n23 VSS.n22 43.8171
R153 VSS.n26 VSS.n24 43.8171
R154 VSS.n26 VSS.n25 43.8171
R155 VSS.n117 VSS.n2 43.8171
R156 VSS.n117 VSS.n116 43.8171
R157 VSS.n115 VSS.n114 43.8171
R158 VSS.n114 VSS.n85 43.8171
R159 VSS.n111 VSS.n87 43.8171
R160 VSS.n111 VSS.n110 43.8171
R161 VSS.n109 VSS.n108 43.8171
R162 VSS.n108 VSS.n88 43.8171
R163 VSS.n106 VSS.n90 43.8171
R164 VSS.n106 VSS.n105 43.8171
R165 VSS.n104 VSS.n103 43.8171
R166 VSS.n103 VSS.n102 43.8171
R167 VSS.n101 VSS.n100 43.8171
R168 VSS.n100 VSS.n94 43.8171
R169 VSS.n97 VSS.n95 43.8171
R170 VSS.n97 VSS.n96 43.8171
R171 VSS.n98 VSS.n0 8.45167
R172 VSS.n119 VSS.n118 8.098
R173 VSS.n56 VSS.n54 8.0005
R174 VSS.n56 VSS.n55 8.0005
R175 VSS.n60 VSS.n58 8.0005
R176 VSS.n60 VSS.n59 8.0005
R177 VSS.n64 VSS.n62 8.0005
R178 VSS.n64 VSS.n63 8.0005
R179 VSS.n68 VSS.n66 8.0005
R180 VSS.n68 VSS.n67 8.0005
R181 VSS.n72 VSS.n70 8.0005
R182 VSS.n72 VSS.n71 8.0005
R183 VSS.n76 VSS.n74 8.0005
R184 VSS.n76 VSS.n75 8.0005
R185 VSS.n80 VSS.n78 8.0005
R186 VSS.n80 VSS.n79 8.0005
R187 VSS.n51 VSS.n49 8.0005
R188 VSS.n51 VSS.n50 8.0005
R189 VSS.n47 VSS.n45 8.0005
R190 VSS.n47 VSS.n46 8.0005
R191 VSS.n43 VSS.n41 8.0005
R192 VSS.n43 VSS.n42 8.0005
R193 VSS.n39 VSS.n37 8.0005
R194 VSS.n39 VSS.n38 8.0005
R195 VSS.n35 VSS.n33 8.0005
R196 VSS.n35 VSS.n34 8.0005
R197 VSS.n31 VSS.n29 8.0005
R198 VSS.n31 VSS.n30 8.0005
R199 VSS.n84 VSS.n83 6.938
R200 VSS.n83 VSS.n82 4.5005
R201 VSS VSS.n0 3.973
R202 VSS VSS.n119 3.82703
R203 VSS.n83 VSS 0.563
R204 VSS.n36 VSS.n32 0.384429
R205 VSS.n40 VSS.n36 0.384429
R206 VSS.n44 VSS.n40 0.384429
R207 VSS.n48 VSS.n44 0.384429
R208 VSS.n52 VSS.n48 0.384429
R209 VSS.n81 VSS.n77 0.384429
R210 VSS.n77 VSS.n73 0.384429
R211 VSS.n73 VSS.n69 0.384429
R212 VSS.n69 VSS.n65 0.384429
R213 VSS.n65 VSS.n61 0.384429
R214 VSS.n61 VSS.n57 0.384429
R215 VSS.n107 VSS.n89 0.384429
R216 VSS.n99 VSS.n89 0.384429
R217 VSS.n99 VSS.n98 0.384429
R218 VSS.n16 VSS.n15 0.384429
R219 VSS.n17 VSS.n16 0.384429
R220 VSS.n17 VSS.n3 0.384429
R221 VSS.n27 VSS.n3 0.384429
R222 VSS.n84 VSS.n27 0.384429
R223 VSS.n113 VSS.n84 0.384429
R224 VSS.n113 VSS.n112 0.384429
R225 VSS.n112 VSS.n86 0.384429
R226 VSS.n91 VSS.n86 0.384429
R227 VSS.n92 VSS.n91 0.384429
R228 VSS.n93 VSS.n92 0.384429
R229 VSS.n21 VSS.n20 0.384429
R230 VSS.n21 VSS.n1 0.384429
R231 VSS.n82 VSS.n52 0.192464
R232 VSS.n82 VSS.n81 0.192464
R233 VSS.n118 VSS.n1 0.192464
R234 VSS.n119 VSS.n0 0.0257625
R235 VIP.n4 VIP.t16 568.582
R236 VIP.n4 VIP.t1 568.582
R237 VIP.n5 VIP.t6 568.582
R238 VIP.n5 VIP.t15 568.582
R239 VIP.n3 VIP.t0 568.582
R240 VIP.n3 VIP.t4 568.582
R241 VIP.n1 VIP.t5 568.582
R242 VIP.n1 VIP.t13 568.582
R243 VIP.n0 VIP.t2 568.582
R244 VIP.n0 VIP.t3 568.582
R245 VIP.n12 VIP.t14 568.582
R246 VIP.n12 VIP.t19 568.582
R247 VIP.n13 VIP.t8 568.582
R248 VIP.n13 VIP.t10 568.582
R249 VIP.n11 VIP.t11 568.582
R250 VIP.n11 VIP.t18 568.582
R251 VIP.n9 VIP.t17 568.582
R252 VIP.n9 VIP.t7 568.582
R253 VIP.n8 VIP.t9 568.582
R254 VIP.n8 VIP.t12 568.582
R255 VIP.n6 VIP.n4 161.685
R256 VIP.n2 VIP.n0 161.685
R257 VIP.n14 VIP.n12 161.685
R258 VIP.n10 VIP.n8 161.685
R259 VIP.n6 VIP.n5 161.3
R260 VIP.n7 VIP.n3 161.3
R261 VIP.n2 VIP.n1 161.3
R262 VIP.n14 VIP.n13 161.3
R263 VIP.n15 VIP.n11 161.3
R264 VIP.n10 VIP.n9 161.3
R265 VIP VIP.n7 5.813
R266 VIP VIP.n15 5.813
R267 VIP.n7 VIP.n2 0.384429
R268 VIP.n7 VIP.n6 0.384429
R269 VIP.n15 VIP.n10 0.384429
R270 VIP.n15 VIP.n14 0.384429
R271 IB.n26 IB.t20 294.913
R272 IB.n26 IB.t18 294.913
R273 IB.n27 IB.t34 294.913
R274 IB.n27 IB.t39 294.913
R275 IB.n29 IB.t26 294.913
R276 IB.n29 IB.t16 294.913
R277 IB.n31 IB.t36 294.913
R278 IB.n31 IB.t41 294.913
R279 IB.n33 IB.t4 294.913
R280 IB.n33 IB.t24 294.913
R281 IB.n35 IB.t31 294.913
R282 IB.n35 IB.t37 294.913
R283 IB.n25 IB.t2 294.913
R284 IB.n25 IB.t22 294.913
R285 IB.n23 IB.t32 294.913
R286 IB.n23 IB.t33 294.913
R287 IB.n21 IB.t10 294.913
R288 IB.n21 IB.t0 294.913
R289 IB.n19 IB.t30 294.913
R290 IB.n19 IB.t35 294.913
R291 IB.n17 IB.t8 294.913
R292 IB.n17 IB.t6 294.913
R293 IB.n15 IB.t38 294.913
R294 IB.n15 IB.t28 294.913
R295 IB.n13 IB.t14 294.913
R296 IB.n13 IB.t12 294.913
R297 IB.n12 IB.t40 294.913
R298 IB.n12 IB.t29 294.913
R299 IB.n28 IB.n26 161.685
R300 IB.n14 IB.n12 161.685
R301 IB.n28 IB.n27 161.3
R302 IB.n30 IB.n29 161.3
R303 IB.n32 IB.n31 161.3
R304 IB.n34 IB.n33 161.3
R305 IB.n36 IB.n35 161.3
R306 IB.n37 IB.n25 161.3
R307 IB.n24 IB.n23 161.3
R308 IB.n22 IB.n21 161.3
R309 IB.n20 IB.n19 161.3
R310 IB.n18 IB.n17 161.3
R311 IB.n16 IB.n15 161.3
R312 IB.n14 IB.n13 161.3
R313 IB.n8 IB.n6 142.791
R314 IB.n2 IB.n0 142.791
R315 IB.n8 IB.n7 142.023
R316 IB.n10 IB.n9 142.023
R317 IB.n11 IB.n5 142.023
R318 IB.n4 IB.n3 142.023
R319 IB.n2 IB.n1 142.023
R320 IB.n6 IB.t19 8.0005
R321 IB.n6 IB.t21 8.0005
R322 IB.n7 IB.t17 8.0005
R323 IB.n7 IB.t27 8.0005
R324 IB.n9 IB.t25 8.0005
R325 IB.n9 IB.t5 8.0005
R326 IB.n5 IB.t23 8.0005
R327 IB.n5 IB.t3 8.0005
R328 IB.n3 IB.t1 8.0005
R329 IB.n3 IB.t11 8.0005
R330 IB.n1 IB.t7 8.0005
R331 IB.n1 IB.t9 8.0005
R332 IB.n0 IB.t13 8.0005
R333 IB.n0 IB.t15 8.0005
R334 IB IB.n11 5.438
R335 IB IB.n37 5.438
R336 IB.n4 IB.n2 0.768357
R337 IB.n11 IB.n4 0.768357
R338 IB.n11 IB.n10 0.768357
R339 IB.n10 IB.n8 0.768357
R340 IB.n16 IB.n14 0.384429
R341 IB.n18 IB.n16 0.384429
R342 IB.n20 IB.n18 0.384429
R343 IB.n22 IB.n20 0.384429
R344 IB.n24 IB.n22 0.384429
R345 IB.n37 IB.n24 0.384429
R346 IB.n37 IB.n36 0.384429
R347 IB.n36 IB.n34 0.384429
R348 IB.n34 IB.n32 0.384429
R349 IB.n32 IB.n30 0.384429
R350 IB.n30 IB.n28 0.384429
C0 VIN m1_484_2996# 0.624813f
C1 VDD VIP 0.248793f
C2 VOUT VIP 0.009101f
C3 VOUT VDD 0.846628f
C4 IB m1_484_2996# 0.068284f
C5 IB VIN 0.011936f
C6 VIP m1_484_2996# 0.129936f
C7 VDD m1_484_2996# 1.447577f
C8 VIP VIN 0.10132f
C9 VOUT m1_484_2996# 0.168718f
C10 VDD VIN 0.1776f
C11 VOUT VIN -0.105333f
C12 IB VIP 0.012726f
C13 IB VDD 0.194358f
C14 VOUT IB 2.28e-20
C15 VOUT VSS 12.58306f
C16 VDD VSS 30.994715f
C17 IB.t13 VSS 0.007964f
C18 IB.t15 VSS 0.007964f
C19 IB.n0 VSS 0.043132f
C20 IB.t7 VSS 0.007964f
C21 IB.t9 VSS 0.007964f
C22 IB.n1 VSS 0.042936f
C23 IB.n2 VSS 0.083128f
C24 IB.t1 VSS 0.007964f
C25 IB.t11 VSS 0.007964f
C26 IB.n3 VSS 0.042936f
C27 IB.n4 VSS 0.046896f
C28 IB.t23 VSS 0.007964f
C29 IB.t3 VSS 0.007964f
C30 IB.n5 VSS 0.042936f
C31 IB.t19 VSS 0.007964f
C32 IB.t21 VSS 0.007964f
C33 IB.n6 VSS 0.043132f
C34 IB.t17 VSS 0.007964f
C35 IB.t27 VSS 0.007964f
C36 IB.n7 VSS 0.042936f
C37 IB.n8 VSS 0.083128f
C38 IB.t25 VSS 0.007964f
C39 IB.t5 VSS 0.007964f
C40 IB.n9 VSS 0.042936f
C41 IB.n10 VSS 0.046896f
C42 IB.n11 VSS 0.05006f
C43 IB.t29 VSS 0.016531f
C44 IB.t40 VSS 0.016531f
C45 IB.n12 VSS 0.028192f
C46 IB.t12 VSS 0.016531f
C47 IB.t14 VSS 0.016531f
C48 IB.n13 VSS 0.02814f
C49 IB.n14 VSS 0.047877f
C50 IB.t28 VSS 0.016531f
C51 IB.t38 VSS 0.016531f
C52 IB.n15 VSS 0.02814f
C53 IB.n16 VSS 0.025937f
C54 IB.t6 VSS 0.016531f
C55 IB.t8 VSS 0.016531f
C56 IB.n17 VSS 0.02814f
C57 IB.n18 VSS 0.025937f
C58 IB.t35 VSS 0.016531f
C59 IB.t30 VSS 0.016531f
C60 IB.n19 VSS 0.02814f
C61 IB.n20 VSS 0.025937f
C62 IB.t0 VSS 0.016531f
C63 IB.t10 VSS 0.016531f
C64 IB.n21 VSS 0.02814f
C65 IB.n22 VSS 0.025937f
C66 IB.t33 VSS 0.016531f
C67 IB.t32 VSS 0.016531f
C68 IB.n23 VSS 0.02814f
C69 IB.n24 VSS 0.025937f
C70 IB.t22 VSS 0.016531f
C71 IB.t2 VSS 0.016531f
C72 IB.n25 VSS 0.02814f
C73 IB.t18 VSS 0.016531f
C74 IB.t20 VSS 0.016531f
C75 IB.n26 VSS 0.028192f
C76 IB.t39 VSS 0.016531f
C77 IB.t34 VSS 0.016531f
C78 IB.n27 VSS 0.02814f
C79 IB.n28 VSS 0.047877f
C80 IB.t16 VSS 0.016531f
C81 IB.t26 VSS 0.016531f
C82 IB.n29 VSS 0.02814f
C83 IB.n30 VSS 0.025937f
C84 IB.t41 VSS 0.016531f
C85 IB.t36 VSS 0.016531f
C86 IB.n31 VSS 0.02814f
C87 IB.n32 VSS 0.025937f
C88 IB.t24 VSS 0.016531f
C89 IB.t4 VSS 0.016531f
C90 IB.n33 VSS 0.02814f
C91 IB.n34 VSS 0.025937f
C92 IB.t37 VSS 0.016531f
C93 IB.t31 VSS 0.016531f
C94 IB.n35 VSS 0.02814f
C95 IB.n36 VSS 0.025937f
C96 IB.n37 VSS 0.029102f
C97 m2_574_4247.t17 VSS 0.057077f
C98 m2_574_4247.t18 VSS 0.083161f
C99 m2_574_4247.t16 VSS 0.083161f
C100 m2_574_4247.n0 VSS 0.153859f
C101 m2_574_4247.t12 VSS 0.083161f
C102 m2_574_4247.t8 VSS 0.083161f
C103 m2_574_4247.n1 VSS 0.153485f
C104 m2_574_4247.n2 VSS 0.343127f
C105 m2_574_4247.t2 VSS 0.083161f
C106 m2_574_4247.t14 VSS 0.083161f
C107 m2_574_4247.n3 VSS 0.153485f
C108 m2_574_4247.t4 VSS 0.083161f
C109 m2_574_4247.t0 VSS 0.083161f
C110 m2_574_4247.n4 VSS 0.153859f
C111 m2_574_4247.t10 VSS 0.083161f
C112 m2_574_4247.t6 VSS 0.083161f
C113 m2_574_4247.n5 VSS 0.153485f
C114 m2_574_4247.n6 VSS 0.343127f
C115 m2_574_4247.n7 VSS 0.187493f
C116 m2_574_4247.t29 VSS 0.083161f
C117 m2_574_4247.t27 VSS 0.083161f
C118 m2_574_4247.n8 VSS 0.153859f
C119 m2_574_4247.t26 VSS 0.083161f
C120 m2_574_4247.t24 VSS 0.083161f
C121 m2_574_4247.n9 VSS 0.153485f
C122 m2_574_4247.n10 VSS 0.343127f
C123 m2_574_4247.t22 VSS 0.083161f
C124 m2_574_4247.t28 VSS 0.083161f
C125 m2_574_4247.n11 VSS 0.153485f
C126 m2_574_4247.n12 VSS 0.185884f
C127 m2_574_4247.t25 VSS 0.083161f
C128 m2_574_4247.t23 VSS 0.083161f
C129 m2_574_4247.n13 VSS 0.153485f
C130 m2_574_4247.n14 VSS 0.185884f
C131 m2_574_4247.t21 VSS 0.083161f
C132 m2_574_4247.t20 VSS 0.083161f
C133 m2_574_4247.n15 VSS 0.153485f
C134 m2_574_4247.n16 VSS 0.408935f
C135 m2_574_4247.n17 VSS 6.22078f
C136 m2_574_4247.t5 VSS 0.057077f
C137 m2_574_4247.t1 VSS 0.057077f
C138 m2_574_4247.n18 VSS 0.239557f
C139 m2_574_4247.t11 VSS 0.057077f
C140 m2_574_4247.t7 VSS 0.057077f
C141 m2_574_4247.n19 VSS 0.239074f
C142 m2_574_4247.n20 VSS 0.59371f
C143 m2_574_4247.t3 VSS 0.057077f
C144 m2_574_4247.t15 VSS 0.057077f
C145 m2_574_4247.n21 VSS 0.239074f
C146 m2_574_4247.n22 VSS 2.42793f
C147 m2_574_4247.t13 VSS 0.057077f
C148 m2_574_4247.t9 VSS 0.057077f
C149 m2_574_4247.n23 VSS 0.239074f
C150 m2_574_4247.n24 VSS 0.59371f
C151 m2_574_4247.n25 VSS 0.239557f
C152 m2_574_4247.t19 VSS 0.057077f
C153 IB VSS 11.923232f
C154 VIP VSS 3.488552f
C155 m1_484_2996# VSS 9.236412f
C156 VIN VSS 3.460877f
.ends
