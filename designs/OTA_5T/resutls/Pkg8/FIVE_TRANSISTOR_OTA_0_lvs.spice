* NGSPICE file created from FIVE_TRANSISTOR_OTA_0.ext - technology: sky130A

.subckt DCL_PMOS_S_97701525_X4_Y1_1774869069 a_200_252# w_0_0#
X0 a_200_252# a_200_252# w_0_0# w_0_0# sky130_fd_pr__pfet_01v8 ad=0.0882 pd=0.91 as=0.0882 ps=0.91 w=0.63 l=0.15 M=8
.ends

.subckt SCM_NMOS_53863688_X7_Y1_1774869072 a_147_504# a_200_252# a_402_504#
X0 a_147_504# a_200_252# a_200_252# a_147_504# sky130_fd_pr__nfet_01v8 ad=0.0882 pd=0.91 as=0.0882 ps=0.91 w=0.63 l=0.15 M=14
X1 a_402_504# a_200_252# a_147_504# a_147_504# sky130_fd_pr__nfet_01v8 ad=0.0882 pd=0.91 as=0.0882 ps=0.91 w=0.63 l=0.15 M=14
.ends

.subckt PMOS_S_37792923_X4_Y1_1774869071 a_200_252# w_0_0# a_230_504#
X0 a_230_504# a_200_252# w_0_0# w_0_0# sky130_fd_pr__pfet_01v8 ad=0.0882 pd=0.91 as=0.0882 ps=0.91 w=0.63 l=0.15 M=8
.ends

.subckt NMOS_4T_27439438_X9_Y1_1774869070 a_147_504# a_200_252# a_230_504# a_241_1232#
X0 a_147_504# a_200_252# a_230_504# a_241_1232# sky130_fd_pr__nfet_01v8 ad=0.0882 pd=0.91 as=0.0882 ps=0.91 w=0.63 l=0.15 M=18
.ends

.subckt FIVE_TRANSISTOR_OTA_0 IB VOUT VIP VIN VSS VDD
XDCL_PMOS_S_97701525_X4_Y1_1774869069_0 m1_484_1568# VDD DCL_PMOS_S_97701525_X4_Y1_1774869069
XSCM_NMOS_53863688_X7_Y1_1774869072_0 VSS IB m1_2204_1316# SCM_NMOS_53863688_X7_Y1_1774869072
XPMOS_S_37792923_X4_Y1_1774869071_0 m1_484_1568# VDD VOUT PMOS_S_37792923_X4_Y1_1774869071
XNMOS_4T_27439438_X9_Y1_1774869070_0 m1_2204_1316# VIN VOUT VSS NMOS_4T_27439438_X9_Y1_1774869070
XNMOS_4T_27439438_X9_Y1_1774869070_1 m1_2204_1316# VIP m1_484_1568# VSS NMOS_4T_27439438_X9_Y1_1774869070
.ends
