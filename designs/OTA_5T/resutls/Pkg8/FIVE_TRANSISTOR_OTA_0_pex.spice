* NGSPICE file created from FIVE_TRANSISTOR_OTA_0.ext - technology: sky130A

.subckt DCL_PMOS_S_97701525_X4_Y1_1774869069 a_200_252# w_0_0# VSUBS
X0 a_200_252# a_200_252# w_0_0# w_0_0# sky130_fd_pr__pfet_01v8 ad=0.0882 pd=0.91 as=0.0882 ps=0.91 w=0.63 l=0.15
X1 a_200_252# a_200_252# w_0_0# w_0_0# sky130_fd_pr__pfet_01v8 ad=0.0882 pd=0.91 as=0.0882 ps=0.91 w=0.63 l=0.15
X2 w_0_0# a_200_252# a_200_252# w_0_0# sky130_fd_pr__pfet_01v8 ad=0.0882 pd=0.91 as=0.0882 ps=0.91 w=0.63 l=0.15
X3 w_0_0# a_200_252# a_200_252# w_0_0# sky130_fd_pr__pfet_01v8 ad=0.16695 pd=1.79 as=0.0882 ps=0.91 w=0.63 l=0.15
X4 a_200_252# a_200_252# w_0_0# w_0_0# sky130_fd_pr__pfet_01v8 ad=0.0882 pd=0.91 as=0.0882 ps=0.91 w=0.63 l=0.15
X5 a_200_252# a_200_252# w_0_0# w_0_0# sky130_fd_pr__pfet_01v8 ad=0.0882 pd=0.91 as=0.16695 ps=1.79 w=0.63 l=0.15
X6 w_0_0# a_200_252# a_200_252# w_0_0# sky130_fd_pr__pfet_01v8 ad=0.0882 pd=0.91 as=0.0882 ps=0.91 w=0.63 l=0.15
X7 w_0_0# a_200_252# a_200_252# w_0_0# sky130_fd_pr__pfet_01v8 ad=0.0882 pd=0.91 as=0.0882 ps=0.91 w=0.63 l=0.15
C0 a_200_252# w_0_0# 5.91923f
C1 a_200_252# VSUBS 0.579947f
C2 w_0_0# VSUBS 5.1277f
.ends

.subckt SCM_NMOS_53863688_X7_Y1_1774869072 a_147_504# a_200_252# a_402_504#
X0 a_147_504# a_200_252# a_200_252# a_147_504# sky130_fd_pr__nfet_01v8 ad=0.0882 pd=0.91 as=0.0882 ps=0.91 w=0.63 l=0.15
X1 a_200_252# a_200_252# a_147_504# a_147_504# sky130_fd_pr__nfet_01v8 ad=0.0882 pd=0.91 as=0.16695 ps=1.79 w=0.63 l=0.15
X2 a_402_504# a_200_252# a_147_504# a_147_504# sky130_fd_pr__nfet_01v8 ad=0.0882 pd=0.91 as=0.0882 ps=0.91 w=0.63 l=0.15
X3 a_147_504# a_200_252# a_200_252# a_147_504# sky130_fd_pr__nfet_01v8 ad=0.0882 pd=0.91 as=0.0882 ps=0.91 w=0.63 l=0.15
X4 a_200_252# a_200_252# a_147_504# a_147_504# sky130_fd_pr__nfet_01v8 ad=0.0882 pd=0.91 as=0.0882 ps=0.91 w=0.63 l=0.15
X5 a_147_504# a_200_252# a_200_252# a_147_504# sky130_fd_pr__nfet_01v8 ad=0.0882 pd=0.91 as=0.0882 ps=0.91 w=0.63 l=0.15
X6 a_402_504# a_200_252# a_147_504# a_147_504# sky130_fd_pr__nfet_01v8 ad=0.0882 pd=0.91 as=0.0882 ps=0.91 w=0.63 l=0.15
X7 a_402_504# a_200_252# a_147_504# a_147_504# sky130_fd_pr__nfet_01v8 ad=0.0882 pd=0.91 as=0.0882 ps=0.91 w=0.63 l=0.15
X8 a_147_504# a_200_252# a_402_504# a_147_504# sky130_fd_pr__nfet_01v8 ad=0.0882 pd=0.91 as=0.0882 ps=0.91 w=0.63 l=0.15
X9 a_147_504# a_200_252# a_402_504# a_147_504# sky130_fd_pr__nfet_01v8 ad=0.0882 pd=0.91 as=0.0882 ps=0.91 w=0.63 l=0.15
X10 a_402_504# a_200_252# a_147_504# a_147_504# sky130_fd_pr__nfet_01v8 ad=0.0882 pd=0.91 as=0.0882 ps=0.91 w=0.63 l=0.15
X11 a_147_504# a_200_252# a_200_252# a_147_504# sky130_fd_pr__nfet_01v8 ad=0.0882 pd=0.91 as=0.0882 ps=0.91 w=0.63 l=0.15
X12 a_402_504# a_200_252# a_147_504# a_147_504# sky130_fd_pr__nfet_01v8 ad=0.0882 pd=0.91 as=0.0882 ps=0.91 w=0.63 l=0.15
X13 a_147_504# a_200_252# a_402_504# a_147_504# sky130_fd_pr__nfet_01v8 ad=0.0882 pd=0.91 as=0.0882 ps=0.91 w=0.63 l=0.15
X14 a_200_252# a_200_252# a_147_504# a_147_504# sky130_fd_pr__nfet_01v8 ad=0.0882 pd=0.91 as=0.0882 ps=0.91 w=0.63 l=0.15
X15 a_200_252# a_200_252# a_147_504# a_147_504# sky130_fd_pr__nfet_01v8 ad=0.0882 pd=0.91 as=0.0882 ps=0.91 w=0.63 l=0.15
X16 a_147_504# a_200_252# a_200_252# a_147_504# sky130_fd_pr__nfet_01v8 ad=0.0882 pd=0.91 as=0.0882 ps=0.91 w=0.63 l=0.15
X17 a_402_504# a_200_252# a_147_504# a_147_504# sky130_fd_pr__nfet_01v8 ad=0.0882 pd=0.91 as=0.0882 ps=0.91 w=0.63 l=0.15
X18 a_147_504# a_200_252# a_402_504# a_147_504# sky130_fd_pr__nfet_01v8 ad=0.0882 pd=0.91 as=0.0882 ps=0.91 w=0.63 l=0.15
X19 a_147_504# a_200_252# a_402_504# a_147_504# sky130_fd_pr__nfet_01v8 ad=0.0882 pd=0.91 as=0.0882 ps=0.91 w=0.63 l=0.15
X20 a_402_504# a_200_252# a_147_504# a_147_504# sky130_fd_pr__nfet_01v8 ad=0.0882 pd=0.91 as=0.0882 ps=0.91 w=0.63 l=0.15
X21 a_200_252# a_200_252# a_147_504# a_147_504# sky130_fd_pr__nfet_01v8 ad=0.0882 pd=0.91 as=0.0882 ps=0.91 w=0.63 l=0.15
X22 a_200_252# a_200_252# a_147_504# a_147_504# sky130_fd_pr__nfet_01v8 ad=0.0882 pd=0.91 as=0.0882 ps=0.91 w=0.63 l=0.15
X23 a_147_504# a_200_252# a_200_252# a_147_504# sky130_fd_pr__nfet_01v8 ad=0.0882 pd=0.91 as=0.0882 ps=0.91 w=0.63 l=0.15
X24 a_200_252# a_200_252# a_147_504# a_147_504# sky130_fd_pr__nfet_01v8 ad=0.0882 pd=0.91 as=0.0882 ps=0.91 w=0.63 l=0.15
X25 a_147_504# a_200_252# a_402_504# a_147_504# sky130_fd_pr__nfet_01v8 ad=0.0882 pd=0.91 as=0.0882 ps=0.91 w=0.63 l=0.15
X26 a_147_504# a_200_252# a_402_504# a_147_504# sky130_fd_pr__nfet_01v8 ad=0.16695 pd=1.79 as=0.0882 ps=0.91 w=0.63 l=0.15
X27 a_147_504# a_200_252# a_200_252# a_147_504# sky130_fd_pr__nfet_01v8 ad=0.0882 pd=0.91 as=0.0882 ps=0.91 w=0.63 l=0.15
C0 a_402_504# a_200_252# 2.06863f
C1 a_402_504# a_147_504# 6.06012f
C2 a_200_252# a_147_504# 14.158799f
.ends

.subckt PMOS_S_37792923_X4_Y1_1774869071 a_200_252# w_0_0# a_230_504# VSUBS
X0 a_230_504# a_200_252# w_0_0# w_0_0# sky130_fd_pr__pfet_01v8 ad=0.0882 pd=0.91 as=0.0882 ps=0.91 w=0.63 l=0.15
X1 a_230_504# a_200_252# w_0_0# w_0_0# sky130_fd_pr__pfet_01v8 ad=0.0882 pd=0.91 as=0.0882 ps=0.91 w=0.63 l=0.15
X2 w_0_0# a_200_252# a_230_504# w_0_0# sky130_fd_pr__pfet_01v8 ad=0.0882 pd=0.91 as=0.0882 ps=0.91 w=0.63 l=0.15
X3 w_0_0# a_200_252# a_230_504# w_0_0# sky130_fd_pr__pfet_01v8 ad=0.16695 pd=1.79 as=0.0882 ps=0.91 w=0.63 l=0.15
X4 a_230_504# a_200_252# w_0_0# w_0_0# sky130_fd_pr__pfet_01v8 ad=0.0882 pd=0.91 as=0.0882 ps=0.91 w=0.63 l=0.15
X5 a_230_504# a_200_252# w_0_0# w_0_0# sky130_fd_pr__pfet_01v8 ad=0.0882 pd=0.91 as=0.16695 ps=1.79 w=0.63 l=0.15
X6 w_0_0# a_200_252# a_230_504# w_0_0# sky130_fd_pr__pfet_01v8 ad=0.0882 pd=0.91 as=0.0882 ps=0.91 w=0.63 l=0.15
X7 w_0_0# a_200_252# a_230_504# w_0_0# sky130_fd_pr__pfet_01v8 ad=0.0882 pd=0.91 as=0.0882 ps=0.91 w=0.63 l=0.15
C0 a_200_252# w_0_0# 2.37703f
C1 a_230_504# a_200_252# 0.393447f
C2 a_230_504# w_0_0# 2.99843f
C3 a_230_504# VSUBS 0.161483f
C4 a_200_252# VSUBS 0.314374f
C5 w_0_0# VSUBS 5.15084f
.ends

.subckt NMOS_4T_27439438_X9_Y1_1774869070 a_147_504# a_200_252# a_230_504# a_241_1232#
X0 a_147_504# a_200_252# a_230_504# a_241_1232# sky130_fd_pr__nfet_01v8 ad=0.0882 pd=0.91 as=0.0882 ps=0.91 w=0.63 l=0.15
X1 a_230_504# a_200_252# a_147_504# a_241_1232# sky130_fd_pr__nfet_01v8 ad=0.0882 pd=0.91 as=0.16695 ps=1.79 w=0.63 l=0.15
X2 a_147_504# a_200_252# a_230_504# a_241_1232# sky130_fd_pr__nfet_01v8 ad=0.0882 pd=0.91 as=0.0882 ps=0.91 w=0.63 l=0.15
X3 a_147_504# a_200_252# a_230_504# a_241_1232# sky130_fd_pr__nfet_01v8 ad=0.0882 pd=0.91 as=0.0882 ps=0.91 w=0.63 l=0.15
X4 a_230_504# a_200_252# a_147_504# a_241_1232# sky130_fd_pr__nfet_01v8 ad=0.0882 pd=0.91 as=0.0882 ps=0.91 w=0.63 l=0.15
X5 a_230_504# a_200_252# a_147_504# a_241_1232# sky130_fd_pr__nfet_01v8 ad=0.0882 pd=0.91 as=0.0882 ps=0.91 w=0.63 l=0.15
X6 a_147_504# a_200_252# a_230_504# a_241_1232# sky130_fd_pr__nfet_01v8 ad=0.0882 pd=0.91 as=0.0882 ps=0.91 w=0.63 l=0.15
X7 a_230_504# a_200_252# a_147_504# a_241_1232# sky130_fd_pr__nfet_01v8 ad=0.0882 pd=0.91 as=0.0882 ps=0.91 w=0.63 l=0.15
X8 a_230_504# a_200_252# a_147_504# a_241_1232# sky130_fd_pr__nfet_01v8 ad=0.0882 pd=0.91 as=0.0882 ps=0.91 w=0.63 l=0.15
X9 a_147_504# a_200_252# a_230_504# a_241_1232# sky130_fd_pr__nfet_01v8 ad=0.0882 pd=0.91 as=0.0882 ps=0.91 w=0.63 l=0.15
X10 a_230_504# a_200_252# a_147_504# a_241_1232# sky130_fd_pr__nfet_01v8 ad=0.0882 pd=0.91 as=0.0882 ps=0.91 w=0.63 l=0.15
X11 a_147_504# a_200_252# a_230_504# a_241_1232# sky130_fd_pr__nfet_01v8 ad=0.0882 pd=0.91 as=0.0882 ps=0.91 w=0.63 l=0.15
X12 a_147_504# a_200_252# a_230_504# a_241_1232# sky130_fd_pr__nfet_01v8 ad=0.0882 pd=0.91 as=0.0882 ps=0.91 w=0.63 l=0.15
X13 a_230_504# a_200_252# a_147_504# a_241_1232# sky130_fd_pr__nfet_01v8 ad=0.0882 pd=0.91 as=0.0882 ps=0.91 w=0.63 l=0.15
X14 a_230_504# a_200_252# a_147_504# a_241_1232# sky130_fd_pr__nfet_01v8 ad=0.0882 pd=0.91 as=0.0882 ps=0.91 w=0.63 l=0.15
X15 a_147_504# a_200_252# a_230_504# a_241_1232# sky130_fd_pr__nfet_01v8 ad=0.16695 pd=1.79 as=0.0882 ps=0.91 w=0.63 l=0.15
X16 a_230_504# a_200_252# a_147_504# a_241_1232# sky130_fd_pr__nfet_01v8 ad=0.0882 pd=0.91 as=0.0882 ps=0.91 w=0.63 l=0.15
X17 a_147_504# a_200_252# a_230_504# a_241_1232# sky130_fd_pr__nfet_01v8 ad=0.0882 pd=0.91 as=0.0882 ps=0.91 w=0.63 l=0.15
C0 a_147_504# a_200_252# 0.889856f
C1 a_230_504# a_147_504# 6.27164f
C2 a_230_504# a_200_252# 0.885767f
C3 a_230_504# a_241_1232# 0.768142f
C4 a_147_504# a_241_1232# 0.954567f
C5 a_200_252# a_241_1232# 4.55703f
.ends

.subckt FIVE_TRANSISTOR_OTA_0 IB VOUT VIP VIN VSS VDD
XDCL_PMOS_S_97701525_X4_Y1_1774869069_0 m1_484_1568# VDD VSS DCL_PMOS_S_97701525_X4_Y1_1774869069
XSCM_NMOS_53863688_X7_Y1_1774869072_0 VSS IB m1_2204_1316# SCM_NMOS_53863688_X7_Y1_1774869072
XPMOS_S_37792923_X4_Y1_1774869071_0 m1_484_1568# VDD VOUT VSS PMOS_S_37792923_X4_Y1_1774869071
XNMOS_4T_27439438_X9_Y1_1774869070_0 m1_2204_1316# VIN VOUT VSS NMOS_4T_27439438_X9_Y1_1774869070
XNMOS_4T_27439438_X9_Y1_1774869070_1 m1_2204_1316# VIP m1_484_1568# VSS NMOS_4T_27439438_X9_Y1_1774869070
R0 m1_484_1568.n2 m1_484_1568.n4 710.653
R1 m1_484_1568.n34 m1_484_1568.n3 710.653
R2 m1_484_1568.n2 m1_484_1568.n5 710.269
R3 m1_484_1568.n35 m1_484_1568.n34 710.269
R4 m1_484_1568.n26 m1_484_1568.t8 573.581
R5 m1_484_1568.n24 m1_484_1568.t12 573.581
R6 m1_484_1568.n31 m1_484_1568.t0 573.581
R7 m1_484_1568.n29 m1_484_1568.t6 573.581
R8 m1_484_1568.n21 m1_484_1568.t10 573.581
R9 m1_484_1568.n19 m1_484_1568.t14 573.581
R10 m1_484_1568.n16 m1_484_1568.t2 573.581
R11 m1_484_1568.n14 m1_484_1568.t4 573.581
R12 m1_484_1568.n11 m1_484_1568.t22 568.582
R13 m1_484_1568.n11 m1_484_1568.t21 568.582
R14 m1_484_1568.n9 m1_484_1568.t18 568.582
R15 m1_484_1568.n9 m1_484_1568.t16 568.582
R16 m1_484_1568.n7 m1_484_1568.t23 568.582
R17 m1_484_1568.n7 m1_484_1568.t20 568.582
R18 m1_484_1568.n6 m1_484_1568.t19 568.582
R19 m1_484_1568.n6 m1_484_1568.t17 568.582
R20 m1_484_1568.n8 m1_484_1568.n6 161.685
R21 m1_484_1568.n1 m1_484_1568.n27 161.685
R22 m1_484_1568.n0 m1_484_1568.n17 161.685
R23 m1_484_1568.n12 m1_484_1568.n11 161.3
R24 m1_484_1568.n10 m1_484_1568.n9 161.3
R25 m1_484_1568.n8 m1_484_1568.n7 161.3
R26 m1_484_1568.n1 m1_484_1568.n32 161.3
R27 m1_484_1568.n0 m1_484_1568.n22 161.3
R28 m1_484_1568.n33 m1_484_1568.n12 63.9126
R29 m1_484_1568.n4 m1_484_1568.t13 43.7783
R30 m1_484_1568.n4 m1_484_1568.t9 43.7783
R31 m1_484_1568.n5 m1_484_1568.t7 43.7783
R32 m1_484_1568.n5 m1_484_1568.t1 43.7783
R33 m1_484_1568.n3 m1_484_1568.t5 43.7783
R34 m1_484_1568.n3 m1_484_1568.t3 43.7783
R35 m1_484_1568.t15 m1_484_1568.n35 43.7783
R36 m1_484_1568.n35 m1_484_1568.t11 43.7783
R37 m1_484_1568.n26 m1_484_1568.n25 33.7405
R38 m1_484_1568.n24 m1_484_1568.n23 33.7405
R39 m1_484_1568.n31 m1_484_1568.n30 33.7405
R40 m1_484_1568.n29 m1_484_1568.n28 33.7405
R41 m1_484_1568.n21 m1_484_1568.n20 33.7405
R42 m1_484_1568.n19 m1_484_1568.n18 33.7405
R43 m1_484_1568.n16 m1_484_1568.n15 33.7405
R44 m1_484_1568.n14 m1_484_1568.n13 33.7405
R45 m1_484_1568.n27 m1_484_1568.n24 24.9931
R46 m1_484_1568.n27 m1_484_1568.n26 24.9931
R47 m1_484_1568.n32 m1_484_1568.n29 24.9931
R48 m1_484_1568.n32 m1_484_1568.n31 24.9931
R49 m1_484_1568.n22 m1_484_1568.n19 24.9931
R50 m1_484_1568.n22 m1_484_1568.n21 24.9931
R51 m1_484_1568.n17 m1_484_1568.n14 24.9931
R52 m1_484_1568.n17 m1_484_1568.n16 24.9931
R53 m1_484_1568.n33 m1_484_1568.n1 6.3755
R54 m1_484_1568.n2 m1_484_1568.n33 4.5005
R55 m1_484_1568.n10 m1_484_1568.n8 0.384429
R56 m1_484_1568.n12 m1_484_1568.n10 0.384429
R57 m1_484_1568.n34 m1_484_1568.n2 0.384429
R58 m1_484_1568.n1 m1_484_1568.n0 0.384429
R59 VDD.n2 VDD.n0 379.685
R60 VDD.n13 VDD.n12 379.685
R61 VDD.n5 VDD.n0 379.3
R62 VDD.n13 VDD.n8 379.3
R63 VDD.n4 VDD.n3 54.0349
R64 VDD.n7 VDD.n6 54.0349
R65 VDD.n10 VDD.n9 54.0349
R66 VDD.n2 VDD.n1 27.0177
R67 VDD.n3 VDD.n2 27.0177
R68 VDD.n5 VDD.n4 27.0177
R69 VDD.n6 VDD.n5 27.0177
R70 VDD.n8 VDD.n7 27.0177
R71 VDD.n9 VDD.n8 27.0177
R72 VDD.n12 VDD.n10 27.0177
R73 VDD.n12 VDD.n11 27.0177
R74 VDD VDD.n13 4.59425
R75 VDD.n13 VDD.n0 0.384429
R76 IB.n37 IB.t24 573.581
R77 IB.n35 IB.t22 573.581
R78 IB.n42 IB.t33 573.581
R79 IB.n40 IB.t37 573.581
R80 IB.n48 IB.t2 573.581
R81 IB.n46 IB.t18 573.581
R82 IB.n54 IB.t34 573.581
R83 IB.n52 IB.t38 573.581
R84 IB.n60 IB.t8 573.581
R85 IB.n58 IB.t0 573.581
R86 IB.n66 IB.t29 573.581
R87 IB.n64 IB.t35 573.581
R88 IB.n32 IB.t6 573.581
R89 IB.n30 IB.t26 573.581
R90 IB.n26 IB.t30 573.581
R91 IB.n24 IB.t31 573.581
R92 IB.n21 IB.t4 568.582
R93 IB.n21 IB.t14 568.582
R94 IB.n19 IB.t32 568.582
R95 IB.n19 IB.t28 568.582
R96 IB.n17 IB.t10 568.582
R97 IB.n17 IB.t12 568.582
R98 IB.n15 IB.t40 568.582
R99 IB.n15 IB.t36 568.582
R100 IB.n13 IB.t16 568.582
R101 IB.n13 IB.t20 568.582
R102 IB.n12 IB.t41 568.582
R103 IB.n12 IB.t39 568.582
R104 IB.n8 IB.n6 311.036
R105 IB.n2 IB.n0 311.036
R106 IB.n8 IB.n7 310.269
R107 IB.n10 IB.n9 310.269
R108 IB.n11 IB.n5 310.269
R109 IB.n4 IB.n3 310.269
R110 IB.n2 IB.n1 310.269
R111 IB.n44 IB.n38 161.685
R112 IB.n14 IB.n12 161.685
R113 IB.n44 IB.n43 161.3
R114 IB.n50 IB.n49 161.3
R115 IB.n56 IB.n55 161.3
R116 IB.n62 IB.n61 161.3
R117 IB.n68 IB.n67 161.3
R118 IB.n69 IB.n33 161.3
R119 IB.n28 IB.n27 161.3
R120 IB.n22 IB.n21 161.3
R121 IB.n20 IB.n19 161.3
R122 IB.n18 IB.n17 161.3
R123 IB.n16 IB.n15 161.3
R124 IB.n14 IB.n13 161.3
R125 IB.n37 IB.n36 33.7405
R126 IB.n35 IB.n34 33.7405
R127 IB.n42 IB.n41 33.7405
R128 IB.n40 IB.n39 33.7405
R129 IB.n48 IB.n47 33.7405
R130 IB.n46 IB.n45 33.7405
R131 IB.n54 IB.n53 33.7405
R132 IB.n52 IB.n51 33.7405
R133 IB.n60 IB.n59 33.7405
R134 IB.n58 IB.n57 33.7405
R135 IB.n66 IB.n65 33.7405
R136 IB.n64 IB.n63 33.7405
R137 IB.n32 IB.n31 33.7405
R138 IB.n30 IB.n29 33.7405
R139 IB.n26 IB.n25 33.7405
R140 IB.n24 IB.n23 33.7405
R141 IB.n6 IB.t23 26.6672
R142 IB.n6 IB.t25 26.6672
R143 IB.n7 IB.t19 26.6672
R144 IB.n7 IB.t3 26.6672
R145 IB.n9 IB.t1 26.6672
R146 IB.n9 IB.t9 26.6672
R147 IB.n5 IB.t27 26.6672
R148 IB.n5 IB.t7 26.6672
R149 IB.n3 IB.t5 26.6672
R150 IB.n3 IB.t15 26.6672
R151 IB.n1 IB.t11 26.6672
R152 IB.n1 IB.t13 26.6672
R153 IB.n0 IB.t17 26.6672
R154 IB.n0 IB.t21 26.6672
R155 IB.n38 IB.n35 24.9931
R156 IB.n38 IB.n37 24.9931
R157 IB.n43 IB.n40 24.9931
R158 IB.n43 IB.n42 24.9931
R159 IB.n49 IB.n46 24.9931
R160 IB.n49 IB.n48 24.9931
R161 IB.n55 IB.n52 24.9931
R162 IB.n55 IB.n54 24.9931
R163 IB.n61 IB.n58 24.9931
R164 IB.n61 IB.n60 24.9931
R165 IB.n67 IB.n64 24.9931
R166 IB.n67 IB.n66 24.9931
R167 IB.n33 IB.n30 24.9931
R168 IB.n33 IB.n32 24.9931
R169 IB.n27 IB.n24 24.9931
R170 IB.n27 IB.n26 24.9931
R171 IB IB.n11 5.438
R172 IB IB.n69 5.438
R173 IB.n4 IB.n2 0.768357
R174 IB.n11 IB.n4 0.768357
R175 IB.n11 IB.n10 0.768357
R176 IB.n10 IB.n8 0.768357
R177 IB.n16 IB.n14 0.384429
R178 IB.n18 IB.n16 0.384429
R179 IB.n20 IB.n18 0.384429
R180 IB.n22 IB.n20 0.384429
R181 IB.n28 IB.n22 0.384429
R182 IB.n69 IB.n28 0.384429
R183 IB.n69 IB.n68 0.384429
R184 IB.n68 IB.n62 0.384429
R185 IB.n62 IB.n56 0.384429
R186 IB.n56 IB.n50 0.384429
R187 IB.n50 IB.n44 0.384429
R188 VSS.n42 VSS.n41 2957.48
R189 VSS.n37 VSS.n3 1179.68
R190 VSS.n25 VSS.n20 1179.68
R191 VSS.n13 VSS.n10 1179.3
R192 VSS.n18 VSS.n17 1179.3
R193 VSS.n20 VSS.n19 1179.3
R194 VSS.n24 VSS.n6 1179.3
R195 VSS.n28 VSS.n27 1179.3
R196 VSS.n30 VSS.n29 1179.3
R197 VSS.n34 VSS.n3 1179.3
R198 VSS.n25 VSS.n24 1179.3
R199 VSS.n27 VSS.n26 1179.3
R200 VSS.n30 VSS.n4 1179.3
R201 VSS.n35 VSS.n34 1179.3
R202 VSS.n37 VSS.n36 1179.3
R203 VSS.n40 VSS.n1 1179.3
R204 VSS.n12 VSS.n11 366.743
R205 VSS.n11 VSS.n0 192.078
R206 VSS.n11 VSS.n10 186.851
R207 VSS.n15 VSS.n14 121.594
R208 VSS.n16 VSS.n9 121.594
R209 VSS.n22 VSS.n21 121.594
R210 VSS.n23 VSS.n7 121.594
R211 VSS.n8 VSS.n5 121.594
R212 VSS.n32 VSS.n31 121.594
R213 VSS.n33 VSS.n2 121.594
R214 VSS.n39 VSS.n38 121.594
R215 VSS.n13 VSS.n12 60.7974
R216 VSS.n14 VSS.n13 60.7974
R217 VSS.n17 VSS.n15 60.7974
R218 VSS.n17 VSS.n16 60.7974
R219 VSS.n20 VSS.n9 60.7974
R220 VSS.n21 VSS.n20 60.7974
R221 VSS.n24 VSS.n22 60.7974
R222 VSS.n24 VSS.n23 60.7974
R223 VSS.n27 VSS.n7 60.7974
R224 VSS.n27 VSS.n8 60.7974
R225 VSS.n30 VSS.n5 60.7974
R226 VSS.n31 VSS.n30 60.7974
R227 VSS.n34 VSS.n32 60.7974
R228 VSS.n34 VSS.n33 60.7974
R229 VSS.n37 VSS.n2 60.7974
R230 VSS.n38 VSS.n37 60.7974
R231 VSS.n40 VSS.n39 60.7974
R232 VSS.n41 VSS.n40 60.7974
R233 VSS.n43 VSS.n42 11.0087
R234 VSS.n10 VSS 7.5005
R235 VSS VSS.n0 3.973
R236 VSS VSS.n43 3.58615
R237 VSS.n42 VSS.n1 0.576862
R238 VSS.n18 VSS.n10 0.384429
R239 VSS.n19 VSS.n18 0.384429
R240 VSS.n19 VSS.n6 0.384429
R241 VSS.n28 VSS.n6 0.384429
R242 VSS.n29 VSS.n28 0.384429
R243 VSS.n29 VSS.n3 0.384429
R244 VSS.n26 VSS.n25 0.384429
R245 VSS.n26 VSS.n4 0.384429
R246 VSS.n35 VSS.n4 0.384429
R247 VSS.n36 VSS.n35 0.384429
R248 VSS.n36 VSS.n1 0.384429
R249 VSS.n43 VSS.n0 0.0375125
R250 VIN.n8 VIN.t15 568.582
R251 VIN.n8 VIN.t10 568.582
R252 VIN.n9 VIN.t6 568.582
R253 VIN.n9 VIN.t5 568.582
R254 VIN.n11 VIN.t0 568.582
R255 VIN.n11 VIN.t14 568.582
R256 VIN.n13 VIN.t9 568.582
R257 VIN.n13 VIN.t4 568.582
R258 VIN.n7 VIN.t17 568.582
R259 VIN.n7 VIN.t13 568.582
R260 VIN.n5 VIN.t12 568.582
R261 VIN.n5 VIN.t8 568.582
R262 VIN.n3 VIN.t3 568.582
R263 VIN.n3 VIN.t16 568.582
R264 VIN.n1 VIN.t11 568.582
R265 VIN.n1 VIN.t7 568.582
R266 VIN.n0 VIN.t2 568.582
R267 VIN.n0 VIN.t1 568.582
R268 VIN.n10 VIN.n8 161.685
R269 VIN.n2 VIN.n0 161.685
R270 VIN.n10 VIN.n9 161.3
R271 VIN.n12 VIN.n11 161.3
R272 VIN.n14 VIN.n13 161.3
R273 VIN VIN.n7 161.3
R274 VIN.n6 VIN.n5 161.3
R275 VIN.n4 VIN.n3 161.3
R276 VIN.n2 VIN.n1 161.3
R277 VIN.n4 VIN.n2 0.384429
R278 VIN.n6 VIN.n4 0.384429
R279 VIN VIN.n6 0.384429
R280 VIN VIN.n14 0.384429
R281 VIN.n14 VIN.n12 0.384429
R282 VIN.n12 VIN.n10 0.384429
R283 VIP.n8 VIP.t1 568.582
R284 VIP.n8 VIP.t2 568.582
R285 VIP.n9 VIP.t7 568.582
R286 VIP.n9 VIP.t11 568.582
R287 VIP.n11 VIP.t16 568.582
R288 VIP.n11 VIP.t3 568.582
R289 VIP.n13 VIP.t8 568.582
R290 VIP.n13 VIP.t12 568.582
R291 VIP.n7 VIP.t13 568.582
R292 VIP.n7 VIP.t17 568.582
R293 VIP.n5 VIP.t4 568.582
R294 VIP.n5 VIP.t9 568.582
R295 VIP.n3 VIP.t14 568.582
R296 VIP.n3 VIP.t0 568.582
R297 VIP.n1 VIP.t5 568.582
R298 VIP.n1 VIP.t6 568.582
R299 VIP.n0 VIP.t10 568.582
R300 VIP.n0 VIP.t15 568.582
R301 VIP.n10 VIP.n8 161.685
R302 VIP.n2 VIP.n0 161.685
R303 VIP.n10 VIP.n9 161.3
R304 VIP.n12 VIP.n11 161.3
R305 VIP.n14 VIP.n13 161.3
R306 VIP VIP.n7 161.3
R307 VIP.n6 VIP.n5 161.3
R308 VIP.n4 VIP.n3 161.3
R309 VIP.n2 VIP.n1 161.3
R310 VIP.n4 VIP.n2 0.384429
R311 VIP.n6 VIP.n4 0.384429
R312 VIP VIP.n6 0.384429
R313 VIP VIP.n14 0.384429
R314 VIP.n14 VIP.n12 0.384429
R315 VIP.n12 VIP.n10 0.384429
C0 VIP IB 0.013389f
C1 VOUT IB 0.236516f
C2 VIP m1_2204_1316# 0.002476f
C3 VIP VIN 0.039365f
C4 m1_2204_1316# IB 0.144067f
C5 VIN IB 0.013133f
C6 VIP VDD 0.007035f
C7 VDD IB 0.194038f
C8 m1_2204_1316# VOUT 0.083418f
C9 VOUT VIN 9.05e-19
C10 m1_2204_1316# VIN 0.002656f
C11 VOUT VDD 0.1025f
C12 m1_2204_1316# VDD 0.09415f
C13 VDD VIN 0.00711f
C14 VOUT VSS 10.432096f
C15 IB.t17 VSS 0.003999f
C16 IB.t21 VSS 0.003999f
C17 IB.n0 VSS 0.030199f
C18 IB.t11 VSS 0.003999f
C19 IB.t13 VSS 0.003999f
C20 IB.n1 VSS 0.029992f
C21 IB.n2 VSS 0.185683f
C22 IB.t5 VSS 0.003999f
C23 IB.t15 VSS 0.003999f
C24 IB.n3 VSS 0.029992f
C25 IB.n4 VSS 0.101705f
C26 IB.t27 VSS 0.003999f
C27 IB.t7 VSS 0.003999f
C28 IB.n5 VSS 0.029992f
C29 IB.t23 VSS 0.003999f
C30 IB.t25 VSS 0.003999f
C31 IB.n6 VSS 0.030199f
C32 IB.t19 VSS 0.003999f
C33 IB.t3 VSS 0.003999f
C34 IB.n7 VSS 0.029992f
C35 IB.n8 VSS 0.185683f
C36 IB.t1 VSS 0.003999f
C37 IB.t9 VSS 0.003999f
C38 IB.n9 VSS 0.029992f
C39 IB.n10 VSS 0.101705f
C40 IB.n11 VSS 0.107002f
C41 IB.t41 VSS -5.73e-19
C42 IB.t39 VSS -5.73e-19
C43 IB.n12 VSS 0.035934f
C44 IB.t16 VSS -5.73e-19
C45 IB.t20 VSS -5.73e-19
C46 IB.n13 VSS 0.035846f
C47 IB.n14 VSS 0.080137f
C48 IB.t40 VSS -5.73e-19
C49 IB.t36 VSS -5.73e-19
C50 IB.n15 VSS 0.035846f
C51 IB.n16 VSS 0.043413f
C52 IB.t10 VSS -5.73e-19
C53 IB.t12 VSS -5.73e-19
C54 IB.n17 VSS 0.035846f
C55 IB.n18 VSS 0.043413f
C56 IB.t32 VSS -5.73e-19
C57 IB.t28 VSS -5.73e-19
C58 IB.n19 VSS 0.035846f
C59 IB.n20 VSS 0.043413f
C60 IB.t4 VSS -5.73e-19
C61 IB.t14 VSS -5.73e-19
C62 IB.n21 VSS 0.035846f
C63 IB.n22 VSS 0.043413f
C64 IB.t31 VSS -7.14e-19
C65 IB.n23 VSS 0.004999f
C66 IB.n24 VSS 0.014568f
C67 IB.t30 VSS -7.14e-19
C68 IB.n25 VSS 0.004999f
C69 IB.n26 VSS 0.014568f
C70 IB.n27 VSS 0.004748f
C71 IB.n28 VSS 0.043413f
C72 IB.t26 VSS -7.14e-19
C73 IB.n29 VSS 0.004999f
C74 IB.n30 VSS 0.014568f
C75 IB.t6 VSS -7.14e-19
C76 IB.n31 VSS 0.004999f
C77 IB.n32 VSS 0.014568f
C78 IB.n33 VSS 0.004748f
C79 IB.t22 VSS -7.14e-19
C80 IB.n34 VSS 0.004999f
C81 IB.n35 VSS 0.014568f
C82 IB.t24 VSS -7.14e-19
C83 IB.n36 VSS 0.004999f
C84 IB.n37 VSS 0.014568f
C85 IB.n38 VSS 0.004835f
C86 IB.t37 VSS -7.14e-19
C87 IB.n39 VSS 0.004999f
C88 IB.n40 VSS 0.014568f
C89 IB.t33 VSS -7.14e-19
C90 IB.n41 VSS 0.004999f
C91 IB.n42 VSS 0.014568f
C92 IB.n43 VSS 0.004748f
C93 IB.n44 VSS 0.080137f
C94 IB.t18 VSS -7.14e-19
C95 IB.n45 VSS 0.004999f
C96 IB.n46 VSS 0.014568f
C97 IB.t2 VSS -7.14e-19
C98 IB.n47 VSS 0.004999f
C99 IB.n48 VSS 0.014568f
C100 IB.n49 VSS 0.004748f
C101 IB.n50 VSS 0.043413f
C102 IB.t38 VSS -7.14e-19
C103 IB.n51 VSS 0.004999f
C104 IB.n52 VSS 0.014568f
C105 IB.t34 VSS -7.14e-19
C106 IB.n53 VSS 0.004999f
C107 IB.n54 VSS 0.014568f
C108 IB.n55 VSS 0.004748f
C109 IB.n56 VSS 0.043413f
C110 IB.t0 VSS -7.14e-19
C111 IB.n57 VSS 0.004999f
C112 IB.n58 VSS 0.014568f
C113 IB.t8 VSS -7.14e-19
C114 IB.n59 VSS 0.004999f
C115 IB.n60 VSS 0.014568f
C116 IB.n61 VSS 0.004748f
C117 IB.n62 VSS 0.043413f
C118 IB.t35 VSS -7.14e-19
C119 IB.n63 VSS 0.004999f
C120 IB.n64 VSS 0.014568f
C121 IB.t29 VSS -7.14e-19
C122 IB.n65 VSS 0.004999f
C123 IB.n66 VSS 0.014568f
C124 IB.n67 VSS 0.004748f
C125 IB.n68 VSS 0.043413f
C126 IB.n69 VSS 0.04871f
C127 VDD.n0 VSS 0.073531f
C128 VDD.n1 VSS 0.918895f
C129 VDD.n2 VSS 0.157716f
C130 VDD.n3 VSS 0.250608f
C131 VDD.n4 VSS 0.250608f
C132 VDD.n5 VSS 0.157683f
C133 VDD.n6 VSS 0.250608f
C134 VDD.n7 VSS 0.250608f
C135 VDD.n8 VSS 0.157683f
C136 VDD.n9 VSS 0.250608f
C137 VDD.n10 VSS 0.250608f
C138 VDD.n11 VSS 0.918895f
C139 VDD.n12 VSS 0.157716f
C140 VDD.n13 VSS 0.086806f
C141 m1_484_1568.n0 VSS 0.475416f
C142 m1_484_1568.n1 VSS 0.652368f
C143 m1_484_1568.n2 VSS 1.16706f
C144 m1_484_1568.t11 VSS 0.025459f
C145 m1_484_1568.t5 VSS 0.025459f
C146 m1_484_1568.t3 VSS 0.025459f
C147 m1_484_1568.n3 VSS 0.112376f
C148 m1_484_1568.t13 VSS 0.025459f
C149 m1_484_1568.t9 VSS 0.025459f
C150 m1_484_1568.n4 VSS 0.112376f
C151 m1_484_1568.t7 VSS 0.025459f
C152 m1_484_1568.t1 VSS 0.025459f
C153 m1_484_1568.n5 VSS 0.112081f
C154 m1_484_1568.t19 VSS -0.003649f
C155 m1_484_1568.t17 VSS -0.003649f
C156 m1_484_1568.n6 VSS 0.228761f
C157 m1_484_1568.t23 VSS -0.003649f
C158 m1_484_1568.t20 VSS -0.003649f
C159 m1_484_1568.n7 VSS 0.228205f
C160 m1_484_1568.n8 VSS 0.510169f
C161 m1_484_1568.t18 VSS -0.003649f
C162 m1_484_1568.t16 VSS -0.003649f
C163 m1_484_1568.n9 VSS 0.228205f
C164 m1_484_1568.n10 VSS 0.276376f
C165 m1_484_1568.t22 VSS -0.003649f
C166 m1_484_1568.t21 VSS -0.003649f
C167 m1_484_1568.n11 VSS 0.228205f
C168 m1_484_1568.n12 VSS 1.72406f
C169 m1_484_1568.t4 VSS -0.004546f
C170 m1_484_1568.n13 VSS 0.031824f
C171 m1_484_1568.n14 VSS 0.092743f
C172 m1_484_1568.t2 VSS -0.004546f
C173 m1_484_1568.n15 VSS 0.031824f
C174 m1_484_1568.n16 VSS 0.092743f
C175 m1_484_1568.n17 VSS 0.030783f
C176 m1_484_1568.t14 VSS -0.004546f
C177 m1_484_1568.n18 VSS 0.031824f
C178 m1_484_1568.n19 VSS 0.092743f
C179 m1_484_1568.t10 VSS -0.004546f
C180 m1_484_1568.n20 VSS 0.031824f
C181 m1_484_1568.n21 VSS 0.092743f
C182 m1_484_1568.n22 VSS 0.030226f
C183 m1_484_1568.t12 VSS -0.004546f
C184 m1_484_1568.n23 VSS 0.031824f
C185 m1_484_1568.n24 VSS 0.092743f
C186 m1_484_1568.t8 VSS -0.004546f
C187 m1_484_1568.n25 VSS 0.031824f
C188 m1_484_1568.n26 VSS 0.092743f
C189 m1_484_1568.n27 VSS 0.030783f
C190 m1_484_1568.t6 VSS -0.004546f
C191 m1_484_1568.n28 VSS 0.031824f
C192 m1_484_1568.n29 VSS 0.092743f
C193 m1_484_1568.t0 VSS -0.004546f
C194 m1_484_1568.n30 VSS 0.031824f
C195 m1_484_1568.n31 VSS 0.092743f
C196 m1_484_1568.n32 VSS 0.030226f
C197 m1_484_1568.n33 VSS 6.77805f
C198 m1_484_1568.n34 VSS 1.09755f
C199 m1_484_1568.n35 VSS 0.112081f
C200 m1_484_1568.t15 VSS 0.025459f
C201 VIP VSS 4.749373f
C202 m1_2204_1316# VSS 8.719727f
C203 VIN VSS 4.729726f
C204 IB VSS 13.811794f
C205 VDD VSS 21.967045f
.ends
