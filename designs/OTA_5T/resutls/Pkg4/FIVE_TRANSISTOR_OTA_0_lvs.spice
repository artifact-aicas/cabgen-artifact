* NGSPICE file created from FIVE_TRANSISTOR_OTA_0.ext - technology: sky130A

.subckt DCL_PMOS_S_71268420_X5_Y2_1774869003 a_200_252# w_0_0#
X0 a_200_252# a_200_252# w_0_0# w_0_0# sky130_fd_pr__pfet_01v8 ad=0.294 pd=2.38 as=0.5565 ps=4.73 w=2.1 l=0.15 M=20
.ends

.subckt NMOS_4T_52804903_X4_Y2_1774869004 a_230_357# a_200_252# a_147_357# a_241_2408#
X0 a_230_357# a_200_252# a_147_357# a_241_2408# sky130_fd_pr__nfet_01v8 ad=0.294 pd=2.38 as=0.294 ps=2.38 w=2.1 l=0.15 M=16
.ends

.subckt PMOS_S_5261831_X5_Y2_1774869005 a_230_357# a_200_252# w_0_0#
X0 a_230_357# a_200_252# w_0_0# w_0_0# sky130_fd_pr__pfet_01v8 ad=0.294 pd=2.38 as=0.5565 ps=4.73 w=2.1 l=0.15 M=20
.ends

.subckt SCM_NMOS_9937040_X6_Y1_1774869006 a_200_252# a_402_357# a_147_357#
X0 a_402_357# a_200_252# a_147_357# a_147_357# sky130_fd_pr__nfet_01v8 ad=0.294 pd=2.38 as=0.294 ps=2.38 w=2.1 l=0.15 M=12
X1 a_147_357# a_200_252# a_200_252# a_147_357# sky130_fd_pr__nfet_01v8 ad=0.5565 pd=4.73 as=0.294 ps=2.38 w=2.1 l=0.15 M=12
.ends

.subckt FIVE_TRANSISTOR_OTA_0 IB VOUT VIP VIN VSS VDD
XDCL_PMOS_S_71268420_X5_Y2_1774869003_0 m1_570_5180# VDD DCL_PMOS_S_71268420_X5_Y2_1774869003
XNMOS_4T_52804903_X4_Y2_1774869004_1 m1_570_5180# VIP m1_484_2996# VSS NMOS_4T_52804903_X4_Y2_1774869004
XNMOS_4T_52804903_X4_Y2_1774869004_0 VOUT VIN m1_484_2996# VSS NMOS_4T_52804903_X4_Y2_1774869004
XPMOS_S_5261831_X5_Y2_1774869005_0 VOUT m1_570_5180# VDD PMOS_S_5261831_X5_Y2_1774869005
XSCM_NMOS_9937040_X6_Y1_1774869006_0 IB m1_484_2996# VSS SCM_NMOS_9937040_X6_Y1_1774869006
.ends
