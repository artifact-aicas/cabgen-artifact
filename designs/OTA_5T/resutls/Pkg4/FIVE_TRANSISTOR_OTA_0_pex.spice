* NGSPICE file created from FIVE_TRANSISTOR_OTA_0.ext - technology: sky130A

.subckt DCL_PMOS_S_71268420_X5_Y2_1774869003 a_200_252# w_0_0# VSUBS
X0 a_200_252# a_200_252# w_0_0# w_0_0# sky130_fd_pr__pfet_01v8 ad=0.294 pd=2.38 as=0.5565 ps=4.73 w=2.1 l=0.15
X1 w_0_0# a_200_252# a_200_252# w_0_0# sky130_fd_pr__pfet_01v8 ad=0.294 pd=2.38 as=0.294 ps=2.38 w=2.1 l=0.15
X2 w_0_0# a_200_252# a_200_252# w_0_0# sky130_fd_pr__pfet_01v8 ad=0.294 pd=2.38 as=0.294 ps=2.38 w=2.1 l=0.15
X3 a_200_252# a_200_252# w_0_0# w_0_0# sky130_fd_pr__pfet_01v8 ad=0.294 pd=2.38 as=0.294 ps=2.38 w=2.1 l=0.15
X4 a_200_252# a_200_252# w_0_0# w_0_0# sky130_fd_pr__pfet_01v8 ad=0.294 pd=2.38 as=0.294 ps=2.38 w=2.1 l=0.15
X5 w_0_0# a_200_252# a_200_252# w_0_0# sky130_fd_pr__pfet_01v8 ad=0.294 pd=2.38 as=0.294 ps=2.38 w=2.1 l=0.15
X6 a_200_252# a_200_252# w_0_0# w_0_0# sky130_fd_pr__pfet_01v8 ad=0.294 pd=2.38 as=0.294 ps=2.38 w=2.1 l=0.15
X7 a_200_252# a_200_252# w_0_0# w_0_0# sky130_fd_pr__pfet_01v8 ad=0.294 pd=2.38 as=0.5565 ps=4.73 w=2.1 l=0.15
X8 w_0_0# a_200_252# a_200_252# w_0_0# sky130_fd_pr__pfet_01v8 ad=0.294 pd=2.38 as=0.294 ps=2.38 w=2.1 l=0.15
X9 w_0_0# a_200_252# a_200_252# w_0_0# sky130_fd_pr__pfet_01v8 ad=0.294 pd=2.38 as=0.294 ps=2.38 w=2.1 l=0.15
X10 a_200_252# a_200_252# w_0_0# w_0_0# sky130_fd_pr__pfet_01v8 ad=0.294 pd=2.38 as=0.294 ps=2.38 w=2.1 l=0.15
X11 a_200_252# a_200_252# w_0_0# w_0_0# sky130_fd_pr__pfet_01v8 ad=0.294 pd=2.38 as=0.294 ps=2.38 w=2.1 l=0.15
X12 w_0_0# a_200_252# a_200_252# w_0_0# sky130_fd_pr__pfet_01v8 ad=0.294 pd=2.38 as=0.294 ps=2.38 w=2.1 l=0.15
X13 w_0_0# a_200_252# a_200_252# w_0_0# sky130_fd_pr__pfet_01v8 ad=0.294 pd=2.38 as=0.294 ps=2.38 w=2.1 l=0.15
X14 w_0_0# a_200_252# a_200_252# w_0_0# sky130_fd_pr__pfet_01v8 ad=0.294 pd=2.38 as=0.294 ps=2.38 w=2.1 l=0.15
X15 a_200_252# a_200_252# w_0_0# w_0_0# sky130_fd_pr__pfet_01v8 ad=0.294 pd=2.38 as=0.294 ps=2.38 w=2.1 l=0.15
X16 a_200_252# a_200_252# w_0_0# w_0_0# sky130_fd_pr__pfet_01v8 ad=0.294 pd=2.38 as=0.294 ps=2.38 w=2.1 l=0.15
X17 w_0_0# a_200_252# a_200_252# w_0_0# sky130_fd_pr__pfet_01v8 ad=0.5565 pd=4.73 as=0.294 ps=2.38 w=2.1 l=0.15
X18 a_200_252# a_200_252# w_0_0# w_0_0# sky130_fd_pr__pfet_01v8 ad=0.294 pd=2.38 as=0.294 ps=2.38 w=2.1 l=0.15
X19 w_0_0# a_200_252# a_200_252# w_0_0# sky130_fd_pr__pfet_01v8 ad=0.5565 pd=4.73 as=0.294 ps=2.38 w=2.1 l=0.15
C0 w_0_0# a_200_252# 12.4998f
C1 a_200_252# VSUBS 0.959552f
C2 w_0_0# VSUBS 10.1216f
.ends

.subckt NMOS_4T_52804903_X4_Y2_1774869004 a_230_357# a_200_252# a_147_357# a_241_2408#
X0 a_230_357# a_200_252# a_147_357# a_241_2408# sky130_fd_pr__nfet_01v8 ad=0.294 pd=2.38 as=0.294 ps=2.38 w=2.1 l=0.15
X1 a_230_357# a_200_252# a_147_357# a_241_2408# sky130_fd_pr__nfet_01v8 ad=0.294 pd=2.38 as=0.5565 ps=4.73 w=2.1 l=0.15
X2 a_147_357# a_200_252# a_230_357# a_241_2408# sky130_fd_pr__nfet_01v8 ad=0.294 pd=2.38 as=0.294 ps=2.38 w=2.1 l=0.15
X3 a_147_357# a_200_252# a_230_357# a_241_2408# sky130_fd_pr__nfet_01v8 ad=0.294 pd=2.38 as=0.294 ps=2.38 w=2.1 l=0.15
X4 a_230_357# a_200_252# a_147_357# a_241_2408# sky130_fd_pr__nfet_01v8 ad=0.294 pd=2.38 as=0.294 ps=2.38 w=2.1 l=0.15
X5 a_230_357# a_200_252# a_147_357# a_241_2408# sky130_fd_pr__nfet_01v8 ad=0.294 pd=2.38 as=0.294 ps=2.38 w=2.1 l=0.15
X6 a_147_357# a_200_252# a_230_357# a_241_2408# sky130_fd_pr__nfet_01v8 ad=0.294 pd=2.38 as=0.294 ps=2.38 w=2.1 l=0.15
X7 a_230_357# a_200_252# a_147_357# a_241_2408# sky130_fd_pr__nfet_01v8 ad=0.294 pd=2.38 as=0.294 ps=2.38 w=2.1 l=0.15
X8 a_230_357# a_200_252# a_147_357# a_241_2408# sky130_fd_pr__nfet_01v8 ad=0.294 pd=2.38 as=0.5565 ps=4.73 w=2.1 l=0.15
X9 a_147_357# a_200_252# a_230_357# a_241_2408# sky130_fd_pr__nfet_01v8 ad=0.5565 pd=4.73 as=0.294 ps=2.38 w=2.1 l=0.15
X10 a_230_357# a_200_252# a_147_357# a_241_2408# sky130_fd_pr__nfet_01v8 ad=0.294 pd=2.38 as=0.294 ps=2.38 w=2.1 l=0.15
X11 a_147_357# a_200_252# a_230_357# a_241_2408# sky130_fd_pr__nfet_01v8 ad=0.294 pd=2.38 as=0.294 ps=2.38 w=2.1 l=0.15
X12 a_147_357# a_200_252# a_230_357# a_241_2408# sky130_fd_pr__nfet_01v8 ad=0.294 pd=2.38 as=0.294 ps=2.38 w=2.1 l=0.15
X13 a_147_357# a_200_252# a_230_357# a_241_2408# sky130_fd_pr__nfet_01v8 ad=0.5565 pd=4.73 as=0.294 ps=2.38 w=2.1 l=0.15
X14 a_230_357# a_200_252# a_147_357# a_241_2408# sky130_fd_pr__nfet_01v8 ad=0.294 pd=2.38 as=0.294 ps=2.38 w=2.1 l=0.15
X15 a_147_357# a_200_252# a_230_357# a_241_2408# sky130_fd_pr__nfet_01v8 ad=0.294 pd=2.38 as=0.294 ps=2.38 w=2.1 l=0.15
C0 a_230_357# a_147_357# 5.95434f
C1 a_230_357# a_200_252# 1.14599f
C2 a_200_252# a_147_357# 1.12155f
C3 a_230_357# a_241_2408# 0.676504f
C4 a_147_357# a_241_2408# 1.25711f
C5 a_200_252# a_241_2408# 2.97909f
.ends

.subckt PMOS_S_5261831_X5_Y2_1774869005 a_230_357# a_200_252# w_0_0# VSUBS
X0 a_230_357# a_200_252# w_0_0# w_0_0# sky130_fd_pr__pfet_01v8 ad=0.294 pd=2.38 as=0.5565 ps=4.73 w=2.1 l=0.15
X1 w_0_0# a_200_252# a_230_357# w_0_0# sky130_fd_pr__pfet_01v8 ad=0.294 pd=2.38 as=0.294 ps=2.38 w=2.1 l=0.15
X2 w_0_0# a_200_252# a_230_357# w_0_0# sky130_fd_pr__pfet_01v8 ad=0.294 pd=2.38 as=0.294 ps=2.38 w=2.1 l=0.15
X3 a_230_357# a_200_252# w_0_0# w_0_0# sky130_fd_pr__pfet_01v8 ad=0.294 pd=2.38 as=0.294 ps=2.38 w=2.1 l=0.15
X4 a_230_357# a_200_252# w_0_0# w_0_0# sky130_fd_pr__pfet_01v8 ad=0.294 pd=2.38 as=0.294 ps=2.38 w=2.1 l=0.15
X5 w_0_0# a_200_252# a_230_357# w_0_0# sky130_fd_pr__pfet_01v8 ad=0.294 pd=2.38 as=0.294 ps=2.38 w=2.1 l=0.15
X6 a_230_357# a_200_252# w_0_0# w_0_0# sky130_fd_pr__pfet_01v8 ad=0.294 pd=2.38 as=0.294 ps=2.38 w=2.1 l=0.15
X7 a_230_357# a_200_252# w_0_0# w_0_0# sky130_fd_pr__pfet_01v8 ad=0.294 pd=2.38 as=0.5565 ps=4.73 w=2.1 l=0.15
X8 w_0_0# a_200_252# a_230_357# w_0_0# sky130_fd_pr__pfet_01v8 ad=0.294 pd=2.38 as=0.294 ps=2.38 w=2.1 l=0.15
X9 w_0_0# a_200_252# a_230_357# w_0_0# sky130_fd_pr__pfet_01v8 ad=0.294 pd=2.38 as=0.294 ps=2.38 w=2.1 l=0.15
X10 a_230_357# a_200_252# w_0_0# w_0_0# sky130_fd_pr__pfet_01v8 ad=0.294 pd=2.38 as=0.294 ps=2.38 w=2.1 l=0.15
X11 a_230_357# a_200_252# w_0_0# w_0_0# sky130_fd_pr__pfet_01v8 ad=0.294 pd=2.38 as=0.294 ps=2.38 w=2.1 l=0.15
X12 w_0_0# a_200_252# a_230_357# w_0_0# sky130_fd_pr__pfet_01v8 ad=0.294 pd=2.38 as=0.294 ps=2.38 w=2.1 l=0.15
X13 w_0_0# a_200_252# a_230_357# w_0_0# sky130_fd_pr__pfet_01v8 ad=0.294 pd=2.38 as=0.294 ps=2.38 w=2.1 l=0.15
X14 w_0_0# a_200_252# a_230_357# w_0_0# sky130_fd_pr__pfet_01v8 ad=0.294 pd=2.38 as=0.294 ps=2.38 w=2.1 l=0.15
X15 a_230_357# a_200_252# w_0_0# w_0_0# sky130_fd_pr__pfet_01v8 ad=0.294 pd=2.38 as=0.294 ps=2.38 w=2.1 l=0.15
X16 a_230_357# a_200_252# w_0_0# w_0_0# sky130_fd_pr__pfet_01v8 ad=0.294 pd=2.38 as=0.294 ps=2.38 w=2.1 l=0.15
X17 w_0_0# a_200_252# a_230_357# w_0_0# sky130_fd_pr__pfet_01v8 ad=0.5565 pd=4.73 as=0.294 ps=2.38 w=2.1 l=0.15
X18 a_230_357# a_200_252# w_0_0# w_0_0# sky130_fd_pr__pfet_01v8 ad=0.294 pd=2.38 as=0.294 ps=2.38 w=2.1 l=0.15
X19 w_0_0# a_200_252# a_230_357# w_0_0# sky130_fd_pr__pfet_01v8 ad=0.5565 pd=4.73 as=0.294 ps=2.38 w=2.1 l=0.15
C0 a_230_357# a_200_252# 1.34378f
C1 a_230_357# w_0_0# 7.81653f
C2 w_0_0# a_200_252# 4.56212f
C3 a_230_357# VSUBS 0.360876f
C4 a_200_252# VSUBS 0.663184f
C5 w_0_0# VSUBS 10.1093f
.ends

.subckt SCM_NMOS_9937040_X6_Y1_1774869006 a_200_252# a_402_357# a_147_357#
X0 a_402_357# a_200_252# a_147_357# a_147_357# sky130_fd_pr__nfet_01v8 ad=0.294 pd=2.38 as=0.294 ps=2.38 w=2.1 l=0.15
X1 a_147_357# a_200_252# a_200_252# a_147_357# sky130_fd_pr__nfet_01v8 ad=0.5565 pd=4.73 as=0.294 ps=2.38 w=2.1 l=0.15
X2 a_147_357# a_200_252# a_200_252# a_147_357# sky130_fd_pr__nfet_01v8 ad=0.294 pd=2.38 as=0.294 ps=2.38 w=2.1 l=0.15
X3 a_147_357# a_200_252# a_402_357# a_147_357# sky130_fd_pr__nfet_01v8 ad=0.294 pd=2.38 as=0.294 ps=2.38 w=2.1 l=0.15
X4 a_200_252# a_200_252# a_147_357# a_147_357# sky130_fd_pr__nfet_01v8 ad=0.294 pd=2.38 as=0.5565 ps=4.73 w=2.1 l=0.15
X5 a_147_357# a_200_252# a_200_252# a_147_357# sky130_fd_pr__nfet_01v8 ad=0.294 pd=2.38 as=0.294 ps=2.38 w=2.1 l=0.15
X6 a_402_357# a_200_252# a_147_357# a_147_357# sky130_fd_pr__nfet_01v8 ad=0.294 pd=2.38 as=0.294 ps=2.38 w=2.1 l=0.15
X7 a_147_357# a_200_252# a_402_357# a_147_357# sky130_fd_pr__nfet_01v8 ad=0.294 pd=2.38 as=0.294 ps=2.38 w=2.1 l=0.15
X8 a_402_357# a_200_252# a_147_357# a_147_357# sky130_fd_pr__nfet_01v8 ad=0.294 pd=2.38 as=0.294 ps=2.38 w=2.1 l=0.15
X9 a_200_252# a_200_252# a_147_357# a_147_357# sky130_fd_pr__nfet_01v8 ad=0.294 pd=2.38 as=0.294 ps=2.38 w=2.1 l=0.15
X10 a_147_357# a_200_252# a_200_252# a_147_357# sky130_fd_pr__nfet_01v8 ad=0.294 pd=2.38 as=0.294 ps=2.38 w=2.1 l=0.15
X11 a_402_357# a_200_252# a_147_357# a_147_357# sky130_fd_pr__nfet_01v8 ad=0.294 pd=2.38 as=0.294 ps=2.38 w=2.1 l=0.15
X12 a_147_357# a_200_252# a_402_357# a_147_357# sky130_fd_pr__nfet_01v8 ad=0.294 pd=2.38 as=0.294 ps=2.38 w=2.1 l=0.15
X13 a_200_252# a_200_252# a_147_357# a_147_357# sky130_fd_pr__nfet_01v8 ad=0.294 pd=2.38 as=0.294 ps=2.38 w=2.1 l=0.15
X14 a_147_357# a_200_252# a_402_357# a_147_357# sky130_fd_pr__nfet_01v8 ad=0.294 pd=2.38 as=0.294 ps=2.38 w=2.1 l=0.15
X15 a_200_252# a_200_252# a_147_357# a_147_357# sky130_fd_pr__nfet_01v8 ad=0.294 pd=2.38 as=0.294 ps=2.38 w=2.1 l=0.15
X16 a_402_357# a_200_252# a_147_357# a_147_357# sky130_fd_pr__nfet_01v8 ad=0.294 pd=2.38 as=0.294 ps=2.38 w=2.1 l=0.15
X17 a_147_357# a_200_252# a_402_357# a_147_357# sky130_fd_pr__nfet_01v8 ad=0.294 pd=2.38 as=0.294 ps=2.38 w=2.1 l=0.15
X18 a_200_252# a_200_252# a_147_357# a_147_357# sky130_fd_pr__nfet_01v8 ad=0.294 pd=2.38 as=0.294 ps=2.38 w=2.1 l=0.15
X19 a_147_357# a_200_252# a_402_357# a_147_357# sky130_fd_pr__nfet_01v8 ad=0.294 pd=2.38 as=0.294 ps=2.38 w=2.1 l=0.15
X20 a_147_357# a_200_252# a_200_252# a_147_357# sky130_fd_pr__nfet_01v8 ad=0.294 pd=2.38 as=0.294 ps=2.38 w=2.1 l=0.15
X21 a_200_252# a_200_252# a_147_357# a_147_357# sky130_fd_pr__nfet_01v8 ad=0.294 pd=2.38 as=0.294 ps=2.38 w=2.1 l=0.15
X22 a_402_357# a_200_252# a_147_357# a_147_357# sky130_fd_pr__nfet_01v8 ad=0.294 pd=2.38 as=0.294 ps=2.38 w=2.1 l=0.15
X23 a_147_357# a_200_252# a_200_252# a_147_357# sky130_fd_pr__nfet_01v8 ad=0.294 pd=2.38 as=0.294 ps=2.38 w=2.1 l=0.15
C0 a_200_252# a_402_357# 1.63759f
C1 a_402_357# a_147_357# 4.95091f
C2 a_200_252# a_147_357# 10.027499f
.ends

.subckt FIVE_TRANSISTOR_OTA_0 IB VOUT VIP VIN VSS VDD
XDCL_PMOS_S_71268420_X5_Y2_1774869003_0 m1_570_5180# VDD VSS DCL_PMOS_S_71268420_X5_Y2_1774869003
XNMOS_4T_52804903_X4_Y2_1774869004_1 m1_570_5180# VIP m1_484_2996# VSS NMOS_4T_52804903_X4_Y2_1774869004
XNMOS_4T_52804903_X4_Y2_1774869004_0 VOUT VIN m1_484_2996# VSS NMOS_4T_52804903_X4_Y2_1774869004
XPMOS_S_5261831_X5_Y2_1774869005_0 VOUT m1_570_5180# VDD VSS PMOS_S_5261831_X5_Y2_1774869005
XSCM_NMOS_9937040_X6_Y1_1774869006_0 IB m1_484_2996# VSS SCM_NMOS_9937040_X6_Y1_1774869006
R0 m1_570_5180.n7 m1_570_5180.t24 568.582
R1 m1_570_5180.n7 m1_570_5180.t20 568.582
R2 m1_570_5180.n8 m1_570_5180.t6 568.582
R3 m1_570_5180.n8 m1_570_5180.t28 568.582
R4 m1_570_5180.n6 m1_570_5180.t18 568.582
R5 m1_570_5180.n6 m1_570_5180.t10 568.582
R6 m1_570_5180.n4 m1_570_5180.t26 568.582
R7 m1_570_5180.n4 m1_570_5180.t22 568.582
R8 m1_570_5180.n3 m1_570_5180.t16 568.582
R9 m1_570_5180.n3 m1_570_5180.t4 568.582
R10 m1_570_5180.n42 m1_570_5180.t38 568.582
R11 m1_570_5180.n42 m1_570_5180.t36 568.582
R12 m1_570_5180.n43 m1_570_5180.t32 568.582
R13 m1_570_5180.n43 m1_570_5180.t14 568.582
R14 m1_570_5180.n41 m1_570_5180.t2 568.582
R15 m1_570_5180.n41 m1_570_5180.t34 568.582
R16 m1_570_5180.n39 m1_570_5180.t30 568.582
R17 m1_570_5180.n39 m1_570_5180.t12 568.582
R18 m1_570_5180.n38 m1_570_5180.t8 568.582
R19 m1_570_5180.n38 m1_570_5180.t0 568.582
R20 m1_570_5180.n24 m1_570_5180.t57 568.582
R21 m1_570_5180.n24 m1_570_5180.t51 568.582
R22 m1_570_5180.n25 m1_570_5180.t48 568.582
R23 m1_570_5180.n25 m1_570_5180.t46 568.582
R24 m1_570_5180.n23 m1_570_5180.t54 568.582
R25 m1_570_5180.n23 m1_570_5180.t50 568.582
R26 m1_570_5180.n21 m1_570_5180.t45 568.582
R27 m1_570_5180.n21 m1_570_5180.t56 568.582
R28 m1_570_5180.n20 m1_570_5180.t49 568.582
R29 m1_570_5180.n20 m1_570_5180.t47 568.582
R30 m1_570_5180.n32 m1_570_5180.t59 568.582
R31 m1_570_5180.n32 m1_570_5180.t55 568.582
R32 m1_570_5180.n33 m1_570_5180.t53 568.582
R33 m1_570_5180.n33 m1_570_5180.t44 568.582
R34 m1_570_5180.n31 m1_570_5180.t42 568.582
R35 m1_570_5180.n31 m1_570_5180.t58 568.582
R36 m1_570_5180.n29 m1_570_5180.t52 568.582
R37 m1_570_5180.n29 m1_570_5180.t43 568.582
R38 m1_570_5180.n28 m1_570_5180.t41 568.582
R39 m1_570_5180.n28 m1_570_5180.t40 568.582
R40 m1_570_5180.n17 m1_570_5180.n15 224.639
R41 m1_570_5180.n13 m1_570_5180.n11 224.639
R42 m1_570_5180.n2 m1_570_5180.n0 224.639
R43 m1_570_5180.n51 m1_570_5180.n50 224.637
R44 m1_570_5180.n50 m1_570_5180.n49 224.256
R45 m1_570_5180.n48 m1_570_5180.n47 224.256
R46 m1_570_5180.n17 m1_570_5180.n16 224.256
R47 m1_570_5180.n18 m1_570_5180.n14 224.256
R48 m1_570_5180.n13 m1_570_5180.n12 224.256
R49 m1_570_5180.n2 m1_570_5180.n1 224.256
R50 m1_570_5180.n9 m1_570_5180.n7 161.685
R51 m1_570_5180.n5 m1_570_5180.n3 161.685
R52 m1_570_5180.n44 m1_570_5180.n42 161.685
R53 m1_570_5180.n40 m1_570_5180.n38 161.685
R54 m1_570_5180.n26 m1_570_5180.n24 161.685
R55 m1_570_5180.n22 m1_570_5180.n20 161.685
R56 m1_570_5180.n34 m1_570_5180.n32 161.685
R57 m1_570_5180.n30 m1_570_5180.n28 161.685
R58 m1_570_5180.n9 m1_570_5180.n8 161.3
R59 m1_570_5180.n10 m1_570_5180.n6 161.3
R60 m1_570_5180.n5 m1_570_5180.n4 161.3
R61 m1_570_5180.n44 m1_570_5180.n43 161.3
R62 m1_570_5180.n45 m1_570_5180.n41 161.3
R63 m1_570_5180.n40 m1_570_5180.n39 161.3
R64 m1_570_5180.n26 m1_570_5180.n25 161.3
R65 m1_570_5180.n27 m1_570_5180.n23 161.3
R66 m1_570_5180.n22 m1_570_5180.n21 161.3
R67 m1_570_5180.n34 m1_570_5180.n33 161.3
R68 m1_570_5180.n35 m1_570_5180.n31 161.3
R69 m1_570_5180.n30 m1_570_5180.n29 161.3
R70 m1_570_5180.n49 m1_570_5180.t15 13.1338
R71 m1_570_5180.n49 m1_570_5180.t33 13.1338
R72 m1_570_5180.n47 m1_570_5180.t35 13.1338
R73 m1_570_5180.n47 m1_570_5180.t3 13.1338
R74 m1_570_5180.n15 m1_570_5180.t21 13.1338
R75 m1_570_5180.n15 m1_570_5180.t25 13.1338
R76 m1_570_5180.n16 m1_570_5180.t29 13.1338
R77 m1_570_5180.n16 m1_570_5180.t7 13.1338
R78 m1_570_5180.n14 m1_570_5180.t11 13.1338
R79 m1_570_5180.n14 m1_570_5180.t19 13.1338
R80 m1_570_5180.n12 m1_570_5180.t23 13.1338
R81 m1_570_5180.n12 m1_570_5180.t27 13.1338
R82 m1_570_5180.n11 m1_570_5180.t5 13.1338
R83 m1_570_5180.n11 m1_570_5180.t17 13.1338
R84 m1_570_5180.n1 m1_570_5180.t13 13.1338
R85 m1_570_5180.n1 m1_570_5180.t31 13.1338
R86 m1_570_5180.n0 m1_570_5180.t1 13.1338
R87 m1_570_5180.n0 m1_570_5180.t9 13.1338
R88 m1_570_5180.n51 m1_570_5180.t37 13.1338
R89 m1_570_5180.t39 m1_570_5180.n51 13.1338
R90 m1_570_5180.n37 m1_570_5180.n36 11.688
R91 m1_570_5180.n36 m1_570_5180.n27 6.938
R92 m1_570_5180.n19 m1_570_5180.n10 6.3755
R93 m1_570_5180.n48 m1_570_5180.n46 6.3755
R94 m1_570_5180.n36 m1_570_5180.n35 4.688
R95 m1_570_5180.n19 m1_570_5180.n18 4.5005
R96 m1_570_5180.n46 m1_570_5180.n45 4.5005
R97 m1_570_5180.n37 m1_570_5180.n19 0.563
R98 m1_570_5180.n10 m1_570_5180.n5 0.384429
R99 m1_570_5180.n10 m1_570_5180.n9 0.384429
R100 m1_570_5180.n45 m1_570_5180.n40 0.384429
R101 m1_570_5180.n45 m1_570_5180.n44 0.384429
R102 m1_570_5180.n18 m1_570_5180.n13 0.384429
R103 m1_570_5180.n18 m1_570_5180.n17 0.384429
R104 m1_570_5180.n27 m1_570_5180.n22 0.384429
R105 m1_570_5180.n27 m1_570_5180.n26 0.384429
R106 m1_570_5180.n35 m1_570_5180.n30 0.384429
R107 m1_570_5180.n35 m1_570_5180.n34 0.384429
R108 m1_570_5180.n48 m1_570_5180.n2 0.384429
R109 m1_570_5180.n50 m1_570_5180.n48 0.384429
R110 m1_570_5180.n46 m1_570_5180.n37 0.188
R111 VIP.n3 VIP.t2 568.582
R112 VIP.n3 VIP.t1 568.582
R113 VIP.n4 VIP.t12 568.582
R114 VIP.n4 VIP.t4 568.582
R115 VIP.n1 VIP.t3 568.582
R116 VIP.n1 VIP.t0 568.582
R117 VIP.n0 VIP.t13 568.582
R118 VIP.n0 VIP.t5 568.582
R119 VIP.n10 VIP.t11 568.582
R120 VIP.n10 VIP.t8 568.582
R121 VIP.n11 VIP.t6 568.582
R122 VIP.n11 VIP.t14 568.582
R123 VIP.n8 VIP.t15 568.582
R124 VIP.n8 VIP.t10 568.582
R125 VIP.n7 VIP.t9 568.582
R126 VIP.n7 VIP.t7 568.582
R127 VIP.n5 VIP.n3 161.685
R128 VIP.n2 VIP.n0 161.685
R129 VIP.n12 VIP.n10 161.685
R130 VIP.n9 VIP.n7 161.685
R131 VIP.n5 VIP.n4 161.3
R132 VIP.n2 VIP.n1 161.3
R133 VIP.n12 VIP.n11 161.3
R134 VIP.n9 VIP.n8 161.3
R135 VIP VIP.n6 5.813
R136 VIP VIP.n13 5.813
R137 VIP.n6 VIP.n2 0.192464
R138 VIP.n6 VIP.n5 0.192464
R139 VIP.n13 VIP.n9 0.192464
R140 VIP.n13 VIP.n12 0.192464
R141 VSS.n48 VSS.n47 1179.68
R142 VSS.n9 VSS.n8 1179.68
R143 VSS.n42 VSS.n34 1179.68
R144 VSS.n13 VSS.n12 1179.68
R145 VSS.n10 VSS.n9 1179.3
R146 VSS.n16 VSS.n4 1179.3
R147 VSS.n21 VSS.n20 1179.3
R148 VSS.n105 VSS.n104 1179.3
R149 VSS.n103 VSS.n23 1179.3
R150 VSS.n54 VSS.n53 1179.3
R151 VSS.n50 VSS.n24 1179.3
R152 VSS.n32 VSS.n31 1179.3
R153 VSS.n44 VSS.n43 1179.3
R154 VSS.n42 VSS.n41 1179.3
R155 VSS.n47 VSS.n46 1179.3
R156 VSS.n35 VSS.n28 1179.3
R157 VSS.n39 VSS.n38 1179.3
R158 VSS.n14 VSS.n13 1179.3
R159 VSS.n18 VSS.n1 1179.3
R160 VSS.n108 VSS.n107 1179.3
R161 VSS.n80 VSS.n76 840.539
R162 VSS.n59 VSS.n55 840.539
R163 VSS.n80 VSS.n79 99.0144
R164 VSS.n84 VSS.n83 99.0144
R165 VSS.n88 VSS.n87 99.0144
R166 VSS.n92 VSS.n91 99.0144
R167 VSS.n96 VSS.n95 99.0144
R168 VSS.n100 VSS.n99 99.0144
R169 VSS.n75 VSS.n74 99.0144
R170 VSS.n71 VSS.n70 99.0144
R171 VSS.n67 VSS.n66 99.0144
R172 VSS.n63 VSS.n62 99.0144
R173 VSS.n59 VSS.n58 99.0144
R174 VSS.n22 VSS.n3 87.6337
R175 VSS.n26 VSS.n25 87.6337
R176 VSS.n52 VSS.n51 87.6337
R177 VSS.n8 VSS.n7 43.8171
R178 VSS.n8 VSS.n6 43.8171
R179 VSS.n12 VSS.n6 43.8171
R180 VSS.n12 VSS.n11 43.8171
R181 VSS.n11 VSS.n10 43.8171
R182 VSS.n10 VSS.n5 43.8171
R183 VSS.n14 VSS.n5 43.8171
R184 VSS.n15 VSS.n14 43.8171
R185 VSS.n16 VSS.n15 43.8171
R186 VSS.n17 VSS.n16 43.8171
R187 VSS.n18 VSS.n17 43.8171
R188 VSS.n19 VSS.n18 43.8171
R189 VSS.n20 VSS.n19 43.8171
R190 VSS.n20 VSS.n2 43.8171
R191 VSS.n107 VSS.n2 43.8171
R192 VSS.n107 VSS.n106 43.8171
R193 VSS.n106 VSS.n105 43.8171
R194 VSS.n105 VSS.n3 43.8171
R195 VSS.n23 VSS.n22 43.8171
R196 VSS.n25 VSS.n23 43.8171
R197 VSS.n53 VSS.n26 43.8171
R198 VSS.n53 VSS.n52 43.8171
R199 VSS.n51 VSS.n50 43.8171
R200 VSS.n50 VSS.n49 43.8171
R201 VSS.n49 VSS.n48 43.8171
R202 VSS.n48 VSS.n27 43.8171
R203 VSS.n31 VSS.n27 43.8171
R204 VSS.n31 VSS.n29 43.8171
R205 VSS.n46 VSS.n29 43.8171
R206 VSS.n46 VSS.n45 43.8171
R207 VSS.n45 VSS.n44 43.8171
R208 VSS.n44 VSS.n30 43.8171
R209 VSS.n35 VSS.n30 43.8171
R210 VSS.n36 VSS.n35 43.8171
R211 VSS.n41 VSS.n36 43.8171
R212 VSS.n41 VSS.n40 43.8171
R213 VSS.n40 VSS.n39 43.8171
R214 VSS.n39 VSS.n37 43.8171
R215 VSS.n37 VSS.n34 43.8171
R216 VSS.n34 VSS.n33 43.8171
R217 VSS.n38 VSS.n0 8.37589
R218 VSS.n109 VSS.n108 8.098
R219 VSS.n79 VSS.n77 8.0005
R220 VSS.n79 VSS.n78 8.0005
R221 VSS.n83 VSS.n81 8.0005
R222 VSS.n83 VSS.n82 8.0005
R223 VSS.n87 VSS.n85 8.0005
R224 VSS.n87 VSS.n86 8.0005
R225 VSS.n91 VSS.n89 8.0005
R226 VSS.n91 VSS.n90 8.0005
R227 VSS.n95 VSS.n93 8.0005
R228 VSS.n95 VSS.n94 8.0005
R229 VSS.n99 VSS.n97 8.0005
R230 VSS.n99 VSS.n98 8.0005
R231 VSS.n74 VSS.n72 8.0005
R232 VSS.n74 VSS.n73 8.0005
R233 VSS.n70 VSS.n68 8.0005
R234 VSS.n70 VSS.n69 8.0005
R235 VSS.n66 VSS.n64 8.0005
R236 VSS.n66 VSS.n65 8.0005
R237 VSS.n62 VSS.n60 8.0005
R238 VSS.n62 VSS.n61 8.0005
R239 VSS.n58 VSS.n56 8.0005
R240 VSS.n58 VSS.n57 8.0005
R241 VSS.n103 VSS.n102 6.938
R242 VSS.n102 VSS.n101 4.5005
R243 VSS VSS.n0 3.973
R244 VSS VSS.n109 3.82703
R245 VSS.n102 VSS 0.563
R246 VSS.n63 VSS.n59 0.384429
R247 VSS.n67 VSS.n63 0.384429
R248 VSS.n71 VSS.n67 0.384429
R249 VSS.n75 VSS.n71 0.384429
R250 VSS.n100 VSS.n96 0.384429
R251 VSS.n96 VSS.n92 0.384429
R252 VSS.n92 VSS.n88 0.384429
R253 VSS.n88 VSS.n84 0.384429
R254 VSS.n84 VSS.n80 0.384429
R255 VSS.n47 VSS.n28 0.384429
R256 VSS.n38 VSS.n28 0.384429
R257 VSS.n9 VSS.n4 0.384429
R258 VSS.n21 VSS.n4 0.384429
R259 VSS.n104 VSS.n21 0.384429
R260 VSS.n104 VSS.n103 0.384429
R261 VSS.n103 VSS.n54 0.384429
R262 VSS.n54 VSS.n24 0.384429
R263 VSS.n32 VSS.n24 0.384429
R264 VSS.n43 VSS.n32 0.384429
R265 VSS.n43 VSS.n42 0.384429
R266 VSS.n13 VSS.n1 0.384429
R267 VSS.n108 VSS.n1 0.384429
R268 VSS.n101 VSS.n75 0.192464
R269 VSS.n101 VSS.n100 0.192464
R270 VSS.n109 VSS.n0 0.0762875
R271 VIN.n3 VIN.t5 568.582
R272 VIN.n3 VIN.t13 568.582
R273 VIN.n4 VIN.t0 568.582
R274 VIN.n4 VIN.t3 568.582
R275 VIN.n1 VIN.t4 568.582
R276 VIN.n1 VIN.t12 568.582
R277 VIN.n0 VIN.t1 568.582
R278 VIN.n0 VIN.t2 568.582
R279 VIN.n10 VIN.t7 568.582
R280 VIN.n10 VIN.t9 568.582
R281 VIN.n11 VIN.t10 568.582
R282 VIN.n11 VIN.t15 568.582
R283 VIN.n8 VIN.t14 568.582
R284 VIN.n8 VIN.t6 568.582
R285 VIN.n7 VIN.t8 568.582
R286 VIN.n7 VIN.t11 568.582
R287 VIN.n5 VIN.n3 161.685
R288 VIN.n2 VIN.n0 161.685
R289 VIN.n12 VIN.n10 161.685
R290 VIN.n9 VIN.n7 161.685
R291 VIN.n5 VIN.n4 161.3
R292 VIN.n2 VIN.n1 161.3
R293 VIN.n12 VIN.n11 161.3
R294 VIN.n9 VIN.n8 161.3
R295 VIN VIN.n6 5.813
R296 VIN VIN.n13 5.813
R297 VIN.n6 VIN.n2 0.192464
R298 VIN.n6 VIN.n5 0.192464
R299 VIN.n13 VIN.n9 0.192464
R300 VIN.n13 VIN.n12 0.192464
R301 IB.n23 IB.t18 294.913
R302 IB.n23 IB.t16 294.913
R303 IB.n24 IB.t29 294.913
R304 IB.n24 IB.t34 294.913
R305 IB.n26 IB.t24 294.913
R306 IB.n26 IB.t27 294.913
R307 IB.n28 IB.t10 294.913
R308 IB.n28 IB.t4 294.913
R309 IB.n30 IB.t2 294.913
R310 IB.n30 IB.t20 294.913
R311 IB.n22 IB.t28 294.913
R312 IB.n22 IB.t31 294.913
R313 IB.n20 IB.t35 294.913
R314 IB.n20 IB.t25 294.913
R315 IB.n18 IB.t14 294.913
R316 IB.n18 IB.t12 294.913
R317 IB.n16 IB.t8 294.913
R318 IB.n16 IB.t0 294.913
R319 IB.n14 IB.t26 294.913
R320 IB.n14 IB.t30 294.913
R321 IB.n12 IB.t32 294.913
R322 IB.n12 IB.t33 294.913
R323 IB.n11 IB.t6 294.913
R324 IB.n11 IB.t22 294.913
R325 IB.n25 IB.n23 161.685
R326 IB.n13 IB.n11 161.685
R327 IB.n25 IB.n24 161.3
R328 IB.n27 IB.n26 161.3
R329 IB.n29 IB.n28 161.3
R330 IB.n31 IB.n30 161.3
R331 IB.n32 IB.n22 161.3
R332 IB.n21 IB.n20 161.3
R333 IB.n19 IB.n18 161.3
R334 IB.n17 IB.n16 161.3
R335 IB.n15 IB.n14 161.3
R336 IB.n13 IB.n12 161.3
R337 IB.n7 IB.n5 143.174
R338 IB.n2 IB.n0 143.174
R339 IB.n7 IB.n6 142.023
R340 IB.n9 IB.n8 142.023
R341 IB.n4 IB.n3 142.023
R342 IB.n2 IB.n1 142.023
R343 IB.n5 IB.t17 8.0005
R344 IB.n5 IB.t19 8.0005
R345 IB.n6 IB.t5 8.0005
R346 IB.n6 IB.t11 8.0005
R347 IB.n8 IB.t21 8.0005
R348 IB.n8 IB.t3 8.0005
R349 IB.n3 IB.t13 8.0005
R350 IB.n3 IB.t15 8.0005
R351 IB.n1 IB.t1 8.0005
R352 IB.n1 IB.t9 8.0005
R353 IB.n0 IB.t23 8.0005
R354 IB.n0 IB.t7 8.0005
R355 IB IB.n10 5.438
R356 IB IB.n32 5.438
R357 IB.n10 IB.n4 0.768357
R358 IB.n15 IB.n13 0.384429
R359 IB.n17 IB.n15 0.384429
R360 IB.n19 IB.n17 0.384429
R361 IB.n21 IB.n19 0.384429
R362 IB.n32 IB.n21 0.384429
R363 IB.n32 IB.n31 0.384429
R364 IB.n31 IB.n29 0.384429
R365 IB.n29 IB.n27 0.384429
R366 IB.n27 IB.n25 0.384429
R367 IB.n4 IB.n2 0.384429
R368 IB.n10 IB.n9 0.384429
R369 IB.n9 IB.n7 0.384429
C0 VOUT m1_484_2996# 0.373088f
C1 m1_484_2996# IB 0.097664f
C2 VOUT VIP 0.006536f
C3 VOUT VIN -0.090907f
C4 IB VIP 0.006876f
C5 IB VIN 0.006876f
C6 VDD VOUT 0.503722f
C7 VDD IB 0.179221f
C8 m1_484_2996# VIP 0.114057f
C9 m1_484_2996# VIN 0.608512f
C10 VIP VIN 0.082743f
C11 VOUT IB 2.28e-20
C12 VDD m1_484_2996# 1.363587f
C13 VDD VIP 0.135681f
C14 VDD VIN 0.185512f
C15 VOUT VSS 15.227361f
C16 VDD VSS 51.98737f
C17 m1_570_5180.t37 VSS 0.055208f
C18 m1_570_5180.t1 VSS 0.055208f
C19 m1_570_5180.t9 VSS 0.055208f
C20 m1_570_5180.n0 VSS 0.231713f
C21 m1_570_5180.t13 VSS 0.055208f
C22 m1_570_5180.t31 VSS 0.055208f
C23 m1_570_5180.n1 VSS 0.231245f
C24 m1_570_5180.n2 VSS 0.574269f
C25 m1_570_5180.t4 VSS 0.080438f
C26 m1_570_5180.t16 VSS 0.080438f
C27 m1_570_5180.n3 VSS 0.148821f
C28 m1_570_5180.t22 VSS 0.080438f
C29 m1_570_5180.t26 VSS 0.080438f
C30 m1_570_5180.n4 VSS 0.148459f
C31 m1_570_5180.n5 VSS 0.331891f
C32 m1_570_5180.t10 VSS 0.080438f
C33 m1_570_5180.t18 VSS 0.080438f
C34 m1_570_5180.n6 VSS 0.148459f
C35 m1_570_5180.t20 VSS 0.080438f
C36 m1_570_5180.t24 VSS 0.080438f
C37 m1_570_5180.n7 VSS 0.148821f
C38 m1_570_5180.t28 VSS 0.080438f
C39 m1_570_5180.t6 VSS 0.080438f
C40 m1_570_5180.n8 VSS 0.148459f
C41 m1_570_5180.n9 VSS 0.331891f
C42 m1_570_5180.n10 VSS 0.249696f
C43 m1_570_5180.t5 VSS 0.055208f
C44 m1_570_5180.t17 VSS 0.055208f
C45 m1_570_5180.n11 VSS 0.231713f
C46 m1_570_5180.t23 VSS 0.055208f
C47 m1_570_5180.t27 VSS 0.055208f
C48 m1_570_5180.n12 VSS 0.231245f
C49 m1_570_5180.n13 VSS 0.574269f
C50 m1_570_5180.t11 VSS 0.055208f
C51 m1_570_5180.t19 VSS 0.055208f
C52 m1_570_5180.n14 VSS 0.231245f
C53 m1_570_5180.t21 VSS 0.055208f
C54 m1_570_5180.t25 VSS 0.055208f
C55 m1_570_5180.n15 VSS 0.231713f
C56 m1_570_5180.t29 VSS 0.055208f
C57 m1_570_5180.t7 VSS 0.055208f
C58 m1_570_5180.n16 VSS 0.231245f
C59 m1_570_5180.n17 VSS 0.574269f
C60 m1_570_5180.n18 VSS 0.301039f
C61 m1_570_5180.n19 VSS 0.454837f
C62 m1_570_5180.t47 VSS 0.080438f
C63 m1_570_5180.t49 VSS 0.080438f
C64 m1_570_5180.n20 VSS 0.148821f
C65 m1_570_5180.t56 VSS 0.080438f
C66 m1_570_5180.t45 VSS 0.080438f
C67 m1_570_5180.n21 VSS 0.148459f
C68 m1_570_5180.n22 VSS 0.331891f
C69 m1_570_5180.t50 VSS 0.080438f
C70 m1_570_5180.t54 VSS 0.080438f
C71 m1_570_5180.n23 VSS 0.148459f
C72 m1_570_5180.t51 VSS 0.080438f
C73 m1_570_5180.t57 VSS 0.080438f
C74 m1_570_5180.n24 VSS 0.148821f
C75 m1_570_5180.t46 VSS 0.080438f
C76 m1_570_5180.t48 VSS 0.080438f
C77 m1_570_5180.n25 VSS 0.148459f
C78 m1_570_5180.n26 VSS 0.331891f
C79 m1_570_5180.n27 VSS 0.286575f
C80 m1_570_5180.t40 VSS 0.080438f
C81 m1_570_5180.t41 VSS 0.080438f
C82 m1_570_5180.n28 VSS 0.148821f
C83 m1_570_5180.t43 VSS 0.080438f
C84 m1_570_5180.t52 VSS 0.080438f
C85 m1_570_5180.n29 VSS 0.148459f
C86 m1_570_5180.n30 VSS 0.331891f
C87 m1_570_5180.t58 VSS 0.080438f
C88 m1_570_5180.t42 VSS 0.080438f
C89 m1_570_5180.n31 VSS 0.148459f
C90 m1_570_5180.t55 VSS 0.080438f
C91 m1_570_5180.t59 VSS 0.080438f
C92 m1_570_5180.n32 VSS 0.148821f
C93 m1_570_5180.t44 VSS 0.080438f
C94 m1_570_5180.t53 VSS 0.080438f
C95 m1_570_5180.n33 VSS 0.148459f
C96 m1_570_5180.n34 VSS 0.331891f
C97 m1_570_5180.n35 VSS 0.181354f
C98 m1_570_5180.n36 VSS 0.876991f
C99 m1_570_5180.n37 VSS 0.421681f
C100 m1_570_5180.t0 VSS 0.080438f
C101 m1_570_5180.t8 VSS 0.080438f
C102 m1_570_5180.n38 VSS 0.148821f
C103 m1_570_5180.t12 VSS 0.080438f
C104 m1_570_5180.t30 VSS 0.080438f
C105 m1_570_5180.n39 VSS 0.148459f
C106 m1_570_5180.n40 VSS 0.331891f
C107 m1_570_5180.t34 VSS 0.080438f
C108 m1_570_5180.t2 VSS 0.080438f
C109 m1_570_5180.n41 VSS 0.148459f
C110 m1_570_5180.t36 VSS 0.080438f
C111 m1_570_5180.t38 VSS 0.080438f
C112 m1_570_5180.n42 VSS 0.148821f
C113 m1_570_5180.t14 VSS 0.080438f
C114 m1_570_5180.t32 VSS 0.080438f
C115 m1_570_5180.n43 VSS 0.148459f
C116 m1_570_5180.n44 VSS 0.331891f
C117 m1_570_5180.n45 VSS 0.179797f
C118 m1_570_5180.n46 VSS 4.6503f
C119 m1_570_5180.t35 VSS 0.055208f
C120 m1_570_5180.t3 VSS 0.055208f
C121 m1_570_5180.n47 VSS 0.231245f
C122 m1_570_5180.n48 VSS 2.13745f
C123 m1_570_5180.t15 VSS 0.055208f
C124 m1_570_5180.t33 VSS 0.055208f
C125 m1_570_5180.n49 VSS 0.231245f
C126 m1_570_5180.n50 VSS 0.574269f
C127 m1_570_5180.n51 VSS 0.231713f
C128 m1_570_5180.t39 VSS 0.055208f
C129 IB VSS 10.327338f
C130 m1_484_2996# VSS 7.991023f
C131 VIN VSS 2.821169f
C132 VIP VSS 2.983823f
.ends
