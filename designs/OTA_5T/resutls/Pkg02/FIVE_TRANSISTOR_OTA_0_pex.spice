* NGSPICE file created from FIVE_TRANSISTOR_OTA_0.ext - technology: sky130A

.subckt NMOS_4T_70086367_X5_Y1_1772456397 a_230_462# a_200_252# a_147_462# a_241_1232#
X0 a_230_462# a_200_252# a_147_462# a_241_1232# sky130_fd_pr__nfet_01v8 ad=0.147 pd=1.33 as=0.147 ps=1.33 w=1.05 l=0.15
X1 a_230_462# a_200_252# a_147_462# a_241_1232# sky130_fd_pr__nfet_01v8 ad=0.147 pd=1.33 as=0.147 ps=1.33 w=1.05 l=0.15
X2 a_147_462# a_200_252# a_230_462# a_241_1232# sky130_fd_pr__nfet_01v8 ad=0.147 pd=1.33 as=0.147 ps=1.33 w=1.05 l=0.15
X3 a_147_462# a_200_252# a_230_462# a_241_1232# sky130_fd_pr__nfet_01v8 ad=0.147 pd=1.33 as=0.147 ps=1.33 w=1.05 l=0.15
X4 a_230_462# a_200_252# a_147_462# a_241_1232# sky130_fd_pr__nfet_01v8 ad=0.147 pd=1.33 as=0.147 ps=1.33 w=1.05 l=0.15
X5 a_230_462# a_200_252# a_147_462# a_241_1232# sky130_fd_pr__nfet_01v8 ad=0.147 pd=1.33 as=0.147 ps=1.33 w=1.05 l=0.15
X6 a_147_462# a_200_252# a_230_462# a_241_1232# sky130_fd_pr__nfet_01v8 ad=0.27825 pd=2.63 as=0.147 ps=1.33 w=1.05 l=0.15
X7 a_230_462# a_200_252# a_147_462# a_241_1232# sky130_fd_pr__nfet_01v8 ad=0.147 pd=1.33 as=0.27825 ps=2.63 w=1.05 l=0.15
X8 a_147_462# a_200_252# a_230_462# a_241_1232# sky130_fd_pr__nfet_01v8 ad=0.147 pd=1.33 as=0.147 ps=1.33 w=1.05 l=0.15
X9 a_147_462# a_200_252# a_230_462# a_241_1232# sky130_fd_pr__nfet_01v8 ad=0.147 pd=1.33 as=0.147 ps=1.33 w=1.05 l=0.15
C0 a_147_462# a_230_462# 3.45985f
C1 a_200_252# a_147_462# 0.460388f
C2 a_200_252# a_230_462# 0.46324f
C3 a_230_462# a_241_1232# 0.403751f
C4 a_147_462# a_241_1232# 0.678246f
C5 a_200_252# a_241_1232# 2.39376f
.ends

.subckt NMOS_S_12526843_X2_Y1_1772456398 a_230_462# a_200_252# a_147_462#
X0 a_230_462# a_200_252# a_147_462# a_147_462# sky130_fd_pr__nfet_01v8 ad=0.147 pd=1.33 as=0.147 ps=1.33 w=1.05 l=0.15
X1 a_147_462# a_200_252# a_230_462# a_147_462# sky130_fd_pr__nfet_01v8 ad=0.27825 pd=2.63 as=0.147 ps=1.33 w=1.05 l=0.15
X2 a_230_462# a_200_252# a_147_462# a_147_462# sky130_fd_pr__nfet_01v8 ad=0.147 pd=1.33 as=0.27825 ps=2.63 w=1.05 l=0.15
X3 a_147_462# a_200_252# a_230_462# a_147_462# sky130_fd_pr__nfet_01v8 ad=0.147 pd=1.33 as=0.147 ps=1.33 w=1.05 l=0.15
C0 a_200_252# a_230_462# 0.185051f
C1 a_230_462# a_147_462# 1.55452f
C2 a_200_252# a_147_462# 1.36634f
.ends

.subckt DCL_NMOS_S_92974257_X2_Y1_1772456395 a_200_252# a_147_462#
X0 a_200_252# a_200_252# a_147_462# a_147_462# sky130_fd_pr__nfet_01v8 ad=0.147 pd=1.33 as=0.147 ps=1.33 w=1.05 l=0.15
X1 a_147_462# a_200_252# a_200_252# a_147_462# sky130_fd_pr__nfet_01v8 ad=0.27825 pd=2.63 as=0.147 ps=1.33 w=1.05 l=0.15
X2 a_200_252# a_200_252# a_147_462# a_147_462# sky130_fd_pr__nfet_01v8 ad=0.147 pd=1.33 as=0.27825 ps=2.63 w=1.05 l=0.15
X3 a_147_462# a_200_252# a_200_252# a_147_462# sky130_fd_pr__nfet_01v8 ad=0.147 pd=1.33 as=0.147 ps=1.33 w=1.05 l=0.15
C0 a_200_252# a_147_462# 3.60719f
.ends

.subckt PMOS_S_72546662_X5_Y1_1772456399 a_230_462# a_200_252# w_0_0# VSUBS
X0 a_230_462# a_200_252# w_0_0# w_0_0# sky130_fd_pr__pfet_01v8 ad=0.147 pd=1.33 as=0.147 ps=1.33 w=1.05 l=0.15
X1 w_0_0# a_200_252# a_230_462# w_0_0# sky130_fd_pr__pfet_01v8 ad=0.147 pd=1.33 as=0.147 ps=1.33 w=1.05 l=0.15
X2 w_0_0# a_200_252# a_230_462# w_0_0# sky130_fd_pr__pfet_01v8 ad=0.147 pd=1.33 as=0.147 ps=1.33 w=1.05 l=0.15
X3 a_230_462# a_200_252# w_0_0# w_0_0# sky130_fd_pr__pfet_01v8 ad=0.147 pd=1.33 as=0.147 ps=1.33 w=1.05 l=0.15
X4 a_230_462# a_200_252# w_0_0# w_0_0# sky130_fd_pr__pfet_01v8 ad=0.147 pd=1.33 as=0.147 ps=1.33 w=1.05 l=0.15
X5 w_0_0# a_200_252# a_230_462# w_0_0# sky130_fd_pr__pfet_01v8 ad=0.27825 pd=2.63 as=0.147 ps=1.33 w=1.05 l=0.15
X6 a_230_462# a_200_252# w_0_0# w_0_0# sky130_fd_pr__pfet_01v8 ad=0.147 pd=1.33 as=0.27825 ps=2.63 w=1.05 l=0.15
X7 w_0_0# a_200_252# a_230_462# w_0_0# sky130_fd_pr__pfet_01v8 ad=0.147 pd=1.33 as=0.147 ps=1.33 w=1.05 l=0.15
X8 w_0_0# a_200_252# a_230_462# w_0_0# sky130_fd_pr__pfet_01v8 ad=0.147 pd=1.33 as=0.147 ps=1.33 w=1.05 l=0.15
X9 a_230_462# a_200_252# w_0_0# w_0_0# sky130_fd_pr__pfet_01v8 ad=0.147 pd=1.33 as=0.147 ps=1.33 w=1.05 l=0.15
C0 a_200_252# a_230_462# 0.46324f
C1 w_0_0# a_200_252# 2.64737f
C2 w_0_0# a_230_462# 3.72346f
C3 a_230_462# VSUBS 0.20286f
C4 a_200_252# VSUBS 0.342728f
C5 w_0_0# VSUBS 5.87388f
.ends

.subckt DCL_PMOS_S_56423641_X5_Y1_1772456396 a_200_252# w_0_0# VSUBS
X0 a_200_252# a_200_252# w_0_0# w_0_0# sky130_fd_pr__pfet_01v8 ad=0.147 pd=1.33 as=0.147 ps=1.33 w=1.05 l=0.15
X1 w_0_0# a_200_252# a_200_252# w_0_0# sky130_fd_pr__pfet_01v8 ad=0.147 pd=1.33 as=0.147 ps=1.33 w=1.05 l=0.15
X2 w_0_0# a_200_252# a_200_252# w_0_0# sky130_fd_pr__pfet_01v8 ad=0.147 pd=1.33 as=0.147 ps=1.33 w=1.05 l=0.15
X3 a_200_252# a_200_252# w_0_0# w_0_0# sky130_fd_pr__pfet_01v8 ad=0.147 pd=1.33 as=0.147 ps=1.33 w=1.05 l=0.15
X4 a_200_252# a_200_252# w_0_0# w_0_0# sky130_fd_pr__pfet_01v8 ad=0.147 pd=1.33 as=0.147 ps=1.33 w=1.05 l=0.15
X5 w_0_0# a_200_252# a_200_252# w_0_0# sky130_fd_pr__pfet_01v8 ad=0.27825 pd=2.63 as=0.147 ps=1.33 w=1.05 l=0.15
X6 a_200_252# a_200_252# w_0_0# w_0_0# sky130_fd_pr__pfet_01v8 ad=0.147 pd=1.33 as=0.27825 ps=2.63 w=1.05 l=0.15
X7 w_0_0# a_200_252# a_200_252# w_0_0# sky130_fd_pr__pfet_01v8 ad=0.147 pd=1.33 as=0.147 ps=1.33 w=1.05 l=0.15
X8 w_0_0# a_200_252# a_200_252# w_0_0# sky130_fd_pr__pfet_01v8 ad=0.147 pd=1.33 as=0.147 ps=1.33 w=1.05 l=0.15
X9 a_200_252# a_200_252# w_0_0# w_0_0# sky130_fd_pr__pfet_01v8 ad=0.147 pd=1.33 as=0.147 ps=1.33 w=1.05 l=0.15
C0 w_0_0# a_200_252# 6.87719f
C1 a_200_252# VSUBS 0.633522f
C2 w_0_0# VSUBS 5.867721f
.ends

.subckt FIVE_TRANSISTOR_OTA_0 IB VOUT VIP VIN VSS VDD
XNMOS_4T_70086367_X5_Y1_1772456397_0 VOUT VIN m1_914_1400# VSS NMOS_4T_70086367_X5_Y1_1772456397
XNMOS_4T_70086367_X5_Y1_1772456397_1 m1_946_3920# VIP m1_914_1400# VSS NMOS_4T_70086367_X5_Y1_1772456397
XNMOS_S_12526843_X2_Y1_1772456398_0 m1_914_1400# IB VSS NMOS_S_12526843_X2_Y1_1772456398
XDCL_NMOS_S_92974257_X2_Y1_1772456395_0 IB VSS DCL_NMOS_S_92974257_X2_Y1_1772456395
XPMOS_S_72546662_X5_Y1_1772456399_0 VOUT m1_946_3920# VDD VSS PMOS_S_72546662_X5_Y1_1772456399
XDCL_PMOS_S_56423641_X5_Y1_1772456396_0 m1_946_3920# VDD VSS DCL_PMOS_S_56423641_X5_Y1_1772456396
R0 VIN.n4 VIN.t8 568.582
R1 VIN.n4 VIN.t7 568.582
R2 VIN.n5 VIN.t2 568.582
R3 VIN.n5 VIN.t0 568.582
R4 VIN.n3 VIN.t9 568.582
R5 VIN.n3 VIN.t5 568.582
R6 VIN.n1 VIN.t3 568.582
R7 VIN.n1 VIN.t1 568.582
R8 VIN.n0 VIN.t6 568.582
R9 VIN.n0 VIN.t4 568.582
R10 VIN.n6 VIN.n4 161.685
R11 VIN.n2 VIN.n0 161.685
R12 VIN.n6 VIN.n5 161.3
R13 VIN VIN.n3 161.3
R14 VIN.n2 VIN.n1 161.3
R15 VIN VIN.n2 0.384429
R16 VIN VIN.n6 0.384429
R17 VSS.n12 VSS.n6 1179.68
R18 VSS.n9 VSS.n6 1179.68
R19 VSS.n11 VSS.n9 1179.3
R20 VSS.n12 VSS.n11 1179.3
R21 VSS.n14 VSS.n13 1179.3
R22 VSS.n17 VSS.n1 1179.3
R23 VSS.n22 VSS.n21 1179.3
R24 VSS.n5 VSS.n4 731.842
R25 VSS.n4 VSS 576.098
R26 VSS.n4 VSS.n3 368.438
R27 VSS.n8 VSS.n7 120.433
R28 VSS.n10 VSS.n2 120.433
R29 VSS.n16 VSS.n15 120.433
R30 VSS.n19 VSS.n18 120.433
R31 VSS.n6 VSS.n5 60.2169
R32 VSS.n7 VSS.n6 60.2169
R33 VSS.n11 VSS.n8 60.2169
R34 VSS.n11 VSS.n10 60.2169
R35 VSS.n14 VSS.n2 60.2169
R36 VSS.n15 VSS.n14 60.2169
R37 VSS.n17 VSS.n16 60.2169
R38 VSS.n18 VSS.n17 60.2169
R39 VSS.n21 VSS.n19 60.2169
R40 VSS.n21 VSS.n20 60.2169
R41 VSS.n9 VSS.n0 11.473
R42 VSS.n23 VSS.n22 8.098
R43 VSS.n3 VSS 3.92977
R44 VSS VSS.n23 3.66194
R45 VSS.n13 VSS.n12 0.384429
R46 VSS.n13 VSS.n1 0.384429
R47 VSS.n22 VSS.n1 0.384429
R48 VSS.n3 VSS.n0 0.2026
R49 VSS.n23 VSS.n0 0.152075
R50 VIP.n4 VIP.t4 568.582
R51 VIP.n4 VIP.t6 568.582
R52 VIP.n5 VIP.t1 568.582
R53 VIP.n5 VIP.t3 568.582
R54 VIP.n3 VIP.t5 568.582
R55 VIP.n3 VIP.t9 568.582
R56 VIP.n1 VIP.t0 568.582
R57 VIP.n1 VIP.t2 568.582
R58 VIP.n0 VIP.t7 568.582
R59 VIP.n0 VIP.t8 568.582
R60 VIP.n6 VIP.n4 161.685
R61 VIP.n2 VIP.n0 161.685
R62 VIP.n6 VIP.n5 161.3
R63 VIP VIP.n3 161.3
R64 VIP.n2 VIP.n1 161.3
R65 VIP VIP.n2 0.384429
R66 VIP VIP.n6 0.384429
R67 IB.n9 IB.t8 568.582
R68 IB.n9 IB.t9 568.582
R69 IB.n7 IB.t10 568.582
R70 IB.n7 IB.t11 568.582
R71 IB.n4 IB.t0 568.582
R72 IB.n4 IB.t2 568.582
R73 IB.n3 IB.t4 568.582
R74 IB.n3 IB.t6 568.582
R75 IB.n2 IB.n1 185.269
R76 IB.n2 IB.n0 185.269
R77 IB IB.n9 161.493
R78 IB.n5 IB.n4 161.493
R79 IB.n5 IB.n3 161.493
R80 IB.n8 IB.n7 161.3
R81 IB.n1 IB.t1 16.0005
R82 IB.n1 IB.t3 16.0005
R83 IB.n0 IB.t5 16.0005
R84 IB.n0 IB.t7 16.0005
R85 IB.n8 IB.n6 15.0317
R86 IB.n6 IB.n2 6.188
R87 IB.n6 IB.n5 4.688
R88 IB IB.n8 0.192464
C0 VIN VIP 0.036005f
C1 m1_946_3920# VOUT 0.023603f
C2 VIP m1_914_1400# 0.018828f
C3 VDD VOUT 0.136644f
C4 m1_946_3920# VIN 0.009524f
C5 VIN VDD 0.035707f
C6 VIN IB 0.003654f
C7 m1_946_3920# m1_914_1400# 0.032317f
C8 VDD m1_914_1400# 0.316498f
C9 IB m1_914_1400# 0.015475f
C10 m1_946_3920# VIP 0.012075f
C11 VIP VDD 0.066239f
C12 VIP IB 0.004635f
C13 m1_946_3920# VDD 0.7622f
C14 m1_946_3920# IB 2.28e-20
C15 VDD IB 0.062589f
C16 VIN VOUT 0.002527f
C17 m1_914_1400# VOUT 0.075761f
C18 VIN m1_914_1400# 0.114296f
C19 IB VSS 5.228773f
C20 m1_914_1400# VSS 3.44117f
C21 VDD VSS 28.97117f
C22 m1_946_3920# VSS 0.968922f
C23 VIP VSS 2.411482f
C24 VOUT VSS 7.7526f
C25 VIN VSS 2.435609f
.ends
