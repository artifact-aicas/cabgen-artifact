* NGSPICE file created from FIVE_TRANSISTOR_OTA_0.ext - technology: sky130A

.subckt NMOS_4T_70086367_X5_Y1_1772456397 a_230_462# a_200_252# a_147_462# a_241_1232#
X0 a_230_462# a_200_252# a_147_462# a_241_1232# sky130_fd_pr__nfet_01v8 ad=0.147 pd=1.33 as=0.147 ps=1.33 w=1.05 l=0.15 M=10
.ends

.subckt NMOS_S_12526843_X2_Y1_1772456398 a_230_462# a_200_252# a_147_462#
X0 a_230_462# a_200_252# a_147_462# a_147_462# sky130_fd_pr__nfet_01v8 ad=0.147 pd=1.33 as=0.147 ps=1.33 w=1.05 l=0.15 M=4
.ends

.subckt DCL_NMOS_S_92974257_X2_Y1_1772456395 a_200_252# a_147_462#
X0 a_200_252# a_200_252# a_147_462# a_147_462# sky130_fd_pr__nfet_01v8 ad=0.147 pd=1.33 as=0.147 ps=1.33 w=1.05 l=0.15 M=4
.ends

.subckt PMOS_S_72546662_X5_Y1_1772456399 a_230_462# a_200_252# w_0_0#
X0 a_230_462# a_200_252# w_0_0# w_0_0# sky130_fd_pr__pfet_01v8 ad=0.147 pd=1.33 as=0.147 ps=1.33 w=1.05 l=0.15 M=10
.ends

.subckt DCL_PMOS_S_56423641_X5_Y1_1772456396 a_200_252# w_0_0#
X0 a_200_252# a_200_252# w_0_0# w_0_0# sky130_fd_pr__pfet_01v8 ad=0.147 pd=1.33 as=0.147 ps=1.33 w=1.05 l=0.15 M=10
.ends

.subckt FIVE_TRANSISTOR_OTA_0 IB VOUT VIP VIN VSS VDD
XNMOS_4T_70086367_X5_Y1_1772456397_0 VOUT VIN m1_914_1400# VSS NMOS_4T_70086367_X5_Y1_1772456397
XNMOS_4T_70086367_X5_Y1_1772456397_1 m1_946_3920# VIP m1_914_1400# VSS NMOS_4T_70086367_X5_Y1_1772456397
XNMOS_S_12526843_X2_Y1_1772456398_0 m1_914_1400# IB VSS NMOS_S_12526843_X2_Y1_1772456398
XDCL_NMOS_S_92974257_X2_Y1_1772456395_0 IB VSS DCL_NMOS_S_92974257_X2_Y1_1772456395
XPMOS_S_72546662_X5_Y1_1772456399_0 VOUT m1_946_3920# VDD PMOS_S_72546662_X5_Y1_1772456399
XDCL_PMOS_S_56423641_X5_Y1_1772456396_0 m1_946_3920# VDD DCL_PMOS_S_56423641_X5_Y1_1772456396
.ends
