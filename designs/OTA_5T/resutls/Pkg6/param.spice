.param VDD=1.83 VCM=0.83 IB=70u vi=0.1 fi=100000 L1=0.15 L3=0.15 LT=0.15 LB=0.15 W1=15.12 W3=22.68 WT=15.12 WB=15.12 NF1=12 NF3=18 NFT=12 NFB=12
