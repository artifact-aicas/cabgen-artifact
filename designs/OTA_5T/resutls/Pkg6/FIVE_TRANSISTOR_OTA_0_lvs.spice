* NGSPICE file created from FIVE_TRANSISTOR_OTA_0.ext - technology: sky130A

.subckt DCL_PMOS_S_13688038_X6_Y1_1774869037 a_200_252# w_0_0#
X0 w_0_0# a_200_252# a_200_252# w_0_0# sky130_fd_pr__pfet_01v8 ad=0.1764 pd=1.54 as=0.1764 ps=1.54 w=1.26 l=0.15 M=12
.ends

.subckt SCM_NMOS_16984956_X6_Y1_1774869040 a_402_441# a_200_252# a_147_441#
X0 a_147_441# a_200_252# a_200_252# a_147_441# sky130_fd_pr__nfet_01v8 ad=0.1764 pd=1.54 as=0.1764 ps=1.54 w=1.26 l=0.15 M=12
X1 a_147_441# a_200_252# a_402_441# a_147_441# sky130_fd_pr__nfet_01v8 ad=0.1764 pd=1.54 as=0.1764 ps=1.54 w=1.26 l=0.15 M=12
.ends

.subckt NMOS_4T_73049722_X9_Y1_1774869038 a_230_441# a_200_252# a_147_441# a_241_1232#
X0 a_147_441# a_200_252# a_230_441# a_241_1232# sky130_fd_pr__nfet_01v8 ad=0.1764 pd=1.54 as=0.1764 ps=1.54 w=1.26 l=0.15 M=18
.ends

.subckt PMOS_S_86315193_X6_Y1_1774869039 a_230_441# a_200_252# w_0_0#
X0 w_0_0# a_200_252# a_230_441# w_0_0# sky130_fd_pr__pfet_01v8 ad=0.1764 pd=1.54 as=0.1764 ps=1.54 w=1.26 l=0.15 M=12
.ends

.subckt FIVE_TRANSISTOR_OTA_0 IB VOUT VIP VIN VSS VDD
XDCL_PMOS_S_13688038_X6_Y1_1774869037_0 li_1437_571# VDD DCL_PMOS_S_13688038_X6_Y1_1774869037
XSCM_NMOS_16984956_X6_Y1_1774869040_0 m1_2376_1316# IB VSS SCM_NMOS_16984956_X6_Y1_1774869040
XNMOS_4T_73049722_X9_Y1_1774869038_0 VOUT VIN m1_2376_1316# VSS NMOS_4T_73049722_X9_Y1_1774869038
XNMOS_4T_73049722_X9_Y1_1774869038_1 li_1437_571# VIP m1_2376_1316# VSS NMOS_4T_73049722_X9_Y1_1774869038
XPMOS_S_86315193_X6_Y1_1774869039_0 VOUT li_1437_571# VDD PMOS_S_86315193_X6_Y1_1774869039
.ends
