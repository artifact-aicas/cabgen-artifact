* NGSPICE file created from FIVE_TRANSISTOR_OTA_0.ext - technology: sky130A

.subckt DCL_PMOS_S_13688038_X6_Y1_1774869037 a_200_252# w_0_0# VSUBS
X0 w_0_0# a_200_252# a_200_252# w_0_0# sky130_fd_pr__pfet_01v8 ad=0.1764 pd=1.54 as=0.1764 ps=1.54 w=1.26 l=0.15
X1 w_0_0# a_200_252# a_200_252# w_0_0# sky130_fd_pr__pfet_01v8 ad=0.1764 pd=1.54 as=0.1764 ps=1.54 w=1.26 l=0.15
X2 a_200_252# a_200_252# w_0_0# w_0_0# sky130_fd_pr__pfet_01v8 ad=0.1764 pd=1.54 as=0.1764 ps=1.54 w=1.26 l=0.15
X3 a_200_252# a_200_252# w_0_0# w_0_0# sky130_fd_pr__pfet_01v8 ad=0.1764 pd=1.54 as=0.1764 ps=1.54 w=1.26 l=0.15
X4 a_200_252# a_200_252# w_0_0# w_0_0# sky130_fd_pr__pfet_01v8 ad=0.1764 pd=1.54 as=0.1764 ps=1.54 w=1.26 l=0.15
X5 w_0_0# a_200_252# a_200_252# w_0_0# sky130_fd_pr__pfet_01v8 ad=0.3339 pd=3.05 as=0.1764 ps=1.54 w=1.26 l=0.15
X6 w_0_0# a_200_252# a_200_252# w_0_0# sky130_fd_pr__pfet_01v8 ad=0.1764 pd=1.54 as=0.1764 ps=1.54 w=1.26 l=0.15
X7 w_0_0# a_200_252# a_200_252# w_0_0# sky130_fd_pr__pfet_01v8 ad=0.1764 pd=1.54 as=0.1764 ps=1.54 w=1.26 l=0.15
X8 a_200_252# a_200_252# w_0_0# w_0_0# sky130_fd_pr__pfet_01v8 ad=0.1764 pd=1.54 as=0.1764 ps=1.54 w=1.26 l=0.15
X9 a_200_252# a_200_252# w_0_0# w_0_0# sky130_fd_pr__pfet_01v8 ad=0.1764 pd=1.54 as=0.1764 ps=1.54 w=1.26 l=0.15
X10 w_0_0# a_200_252# a_200_252# w_0_0# sky130_fd_pr__pfet_01v8 ad=0.1764 pd=1.54 as=0.1764 ps=1.54 w=1.26 l=0.15
X11 a_200_252# a_200_252# w_0_0# w_0_0# sky130_fd_pr__pfet_01v8 ad=0.1764 pd=1.54 as=0.3339 ps=3.05 w=1.26 l=0.15
C0 w_0_0# a_200_252# 7.99123f
C1 a_200_252# VSUBS 0.691538f
C2 w_0_0# VSUBS 6.61699f
.ends

.subckt SCM_NMOS_16984956_X6_Y1_1774869040 a_402_441# a_200_252# a_147_441#
X0 a_147_441# a_200_252# a_200_252# a_147_441# sky130_fd_pr__nfet_01v8 ad=0.1764 pd=1.54 as=0.1764 ps=1.54 w=1.26 l=0.15
X1 a_147_441# a_200_252# a_402_441# a_147_441# sky130_fd_pr__nfet_01v8 ad=0.1764 pd=1.54 as=0.1764 ps=1.54 w=1.26 l=0.15
X2 a_200_252# a_200_252# a_147_441# a_147_441# sky130_fd_pr__nfet_01v8 ad=0.1764 pd=1.54 as=0.3339 ps=3.05 w=1.26 l=0.15
X3 a_402_441# a_200_252# a_147_441# a_147_441# sky130_fd_pr__nfet_01v8 ad=0.1764 pd=1.54 as=0.1764 ps=1.54 w=1.26 l=0.15
X4 a_147_441# a_200_252# a_200_252# a_147_441# sky130_fd_pr__nfet_01v8 ad=0.1764 pd=1.54 as=0.1764 ps=1.54 w=1.26 l=0.15
X5 a_147_441# a_200_252# a_402_441# a_147_441# sky130_fd_pr__nfet_01v8 ad=0.1764 pd=1.54 as=0.1764 ps=1.54 w=1.26 l=0.15
X6 a_402_441# a_200_252# a_147_441# a_147_441# sky130_fd_pr__nfet_01v8 ad=0.1764 pd=1.54 as=0.1764 ps=1.54 w=1.26 l=0.15
X7 a_200_252# a_200_252# a_147_441# a_147_441# sky130_fd_pr__nfet_01v8 ad=0.1764 pd=1.54 as=0.1764 ps=1.54 w=1.26 l=0.15
X8 a_147_441# a_200_252# a_200_252# a_147_441# sky130_fd_pr__nfet_01v8 ad=0.1764 pd=1.54 as=0.1764 ps=1.54 w=1.26 l=0.15
X9 a_147_441# a_200_252# a_402_441# a_147_441# sky130_fd_pr__nfet_01v8 ad=0.1764 pd=1.54 as=0.1764 ps=1.54 w=1.26 l=0.15
X10 a_402_441# a_200_252# a_147_441# a_147_441# sky130_fd_pr__nfet_01v8 ad=0.1764 pd=1.54 as=0.1764 ps=1.54 w=1.26 l=0.15
X11 a_200_252# a_200_252# a_147_441# a_147_441# sky130_fd_pr__nfet_01v8 ad=0.1764 pd=1.54 as=0.1764 ps=1.54 w=1.26 l=0.15
X12 a_147_441# a_200_252# a_402_441# a_147_441# sky130_fd_pr__nfet_01v8 ad=0.1764 pd=1.54 as=0.1764 ps=1.54 w=1.26 l=0.15
X13 a_200_252# a_200_252# a_147_441# a_147_441# sky130_fd_pr__nfet_01v8 ad=0.1764 pd=1.54 as=0.1764 ps=1.54 w=1.26 l=0.15
X14 a_402_441# a_200_252# a_147_441# a_147_441# sky130_fd_pr__nfet_01v8 ad=0.1764 pd=1.54 as=0.1764 ps=1.54 w=1.26 l=0.15
X15 a_147_441# a_200_252# a_402_441# a_147_441# sky130_fd_pr__nfet_01v8 ad=0.1764 pd=1.54 as=0.1764 ps=1.54 w=1.26 l=0.15
X16 a_200_252# a_200_252# a_147_441# a_147_441# sky130_fd_pr__nfet_01v8 ad=0.1764 pd=1.54 as=0.1764 ps=1.54 w=1.26 l=0.15
X17 a_147_441# a_200_252# a_402_441# a_147_441# sky130_fd_pr__nfet_01v8 ad=0.1764 pd=1.54 as=0.1764 ps=1.54 w=1.26 l=0.15
X18 a_147_441# a_200_252# a_200_252# a_147_441# sky130_fd_pr__nfet_01v8 ad=0.1764 pd=1.54 as=0.1764 ps=1.54 w=1.26 l=0.15
X19 a_200_252# a_200_252# a_147_441# a_147_441# sky130_fd_pr__nfet_01v8 ad=0.1764 pd=1.54 as=0.1764 ps=1.54 w=1.26 l=0.15
X20 a_402_441# a_200_252# a_147_441# a_147_441# sky130_fd_pr__nfet_01v8 ad=0.1764 pd=1.54 as=0.1764 ps=1.54 w=1.26 l=0.15
X21 a_147_441# a_200_252# a_200_252# a_147_441# sky130_fd_pr__nfet_01v8 ad=0.1764 pd=1.54 as=0.1764 ps=1.54 w=1.26 l=0.15
X22 a_402_441# a_200_252# a_147_441# a_147_441# sky130_fd_pr__nfet_01v8 ad=0.1764 pd=1.54 as=0.1764 ps=1.54 w=1.26 l=0.15
X23 a_147_441# a_200_252# a_200_252# a_147_441# sky130_fd_pr__nfet_01v8 ad=0.3339 pd=3.05 as=0.1764 ps=1.54 w=1.26 l=0.15
C0 a_200_252# a_402_441# 1.70235f
C1 a_402_441# a_147_441# 4.99106f
C2 a_200_252# a_147_441# 11.3662f
.ends

.subckt NMOS_4T_73049722_X9_Y1_1774869038 a_230_441# a_200_252# a_147_441# a_241_1232#
X0 a_147_441# a_200_252# a_230_441# a_241_1232# sky130_fd_pr__nfet_01v8 ad=0.1764 pd=1.54 as=0.1764 ps=1.54 w=1.26 l=0.15
X1 a_147_441# a_200_252# a_230_441# a_241_1232# sky130_fd_pr__nfet_01v8 ad=0.1764 pd=1.54 as=0.1764 ps=1.54 w=1.26 l=0.15
X2 a_230_441# a_200_252# a_147_441# a_241_1232# sky130_fd_pr__nfet_01v8 ad=0.1764 pd=1.54 as=0.3339 ps=3.05 w=1.26 l=0.15
X3 a_147_441# a_200_252# a_230_441# a_241_1232# sky130_fd_pr__nfet_01v8 ad=0.1764 pd=1.54 as=0.1764 ps=1.54 w=1.26 l=0.15
X4 a_147_441# a_200_252# a_230_441# a_241_1232# sky130_fd_pr__nfet_01v8 ad=0.1764 pd=1.54 as=0.1764 ps=1.54 w=1.26 l=0.15
X5 a_230_441# a_200_252# a_147_441# a_241_1232# sky130_fd_pr__nfet_01v8 ad=0.1764 pd=1.54 as=0.1764 ps=1.54 w=1.26 l=0.15
X6 a_230_441# a_200_252# a_147_441# a_241_1232# sky130_fd_pr__nfet_01v8 ad=0.1764 pd=1.54 as=0.1764 ps=1.54 w=1.26 l=0.15
X7 a_147_441# a_200_252# a_230_441# a_241_1232# sky130_fd_pr__nfet_01v8 ad=0.1764 pd=1.54 as=0.1764 ps=1.54 w=1.26 l=0.15
X8 a_230_441# a_200_252# a_147_441# a_241_1232# sky130_fd_pr__nfet_01v8 ad=0.1764 pd=1.54 as=0.1764 ps=1.54 w=1.26 l=0.15
X9 a_230_441# a_200_252# a_147_441# a_241_1232# sky130_fd_pr__nfet_01v8 ad=0.1764 pd=1.54 as=0.1764 ps=1.54 w=1.26 l=0.15
X10 a_147_441# a_200_252# a_230_441# a_241_1232# sky130_fd_pr__nfet_01v8 ad=0.1764 pd=1.54 as=0.1764 ps=1.54 w=1.26 l=0.15
X11 a_230_441# a_200_252# a_147_441# a_241_1232# sky130_fd_pr__nfet_01v8 ad=0.1764 pd=1.54 as=0.1764 ps=1.54 w=1.26 l=0.15
X12 a_147_441# a_200_252# a_230_441# a_241_1232# sky130_fd_pr__nfet_01v8 ad=0.1764 pd=1.54 as=0.1764 ps=1.54 w=1.26 l=0.15
X13 a_147_441# a_200_252# a_230_441# a_241_1232# sky130_fd_pr__nfet_01v8 ad=0.1764 pd=1.54 as=0.1764 ps=1.54 w=1.26 l=0.15
X14 a_230_441# a_200_252# a_147_441# a_241_1232# sky130_fd_pr__nfet_01v8 ad=0.1764 pd=1.54 as=0.1764 ps=1.54 w=1.26 l=0.15
X15 a_230_441# a_200_252# a_147_441# a_241_1232# sky130_fd_pr__nfet_01v8 ad=0.1764 pd=1.54 as=0.1764 ps=1.54 w=1.26 l=0.15
X16 a_147_441# a_200_252# a_230_441# a_241_1232# sky130_fd_pr__nfet_01v8 ad=0.3339 pd=3.05 as=0.1764 ps=1.54 w=1.26 l=0.15
X17 a_230_441# a_200_252# a_147_441# a_241_1232# sky130_fd_pr__nfet_01v8 ad=0.1764 pd=1.54 as=0.1764 ps=1.54 w=1.26 l=0.15
C0 a_230_441# a_147_441# 6.28317f
C1 a_200_252# a_147_441# 0.812297f
C2 a_200_252# a_230_441# 0.808372f
C3 a_230_441# a_241_1232# 0.70924f
C4 a_147_441# a_241_1232# 0.876148f
C5 a_200_252# a_241_1232# 3.90018f
.ends

.subckt PMOS_S_86315193_X6_Y1_1774869039 a_230_441# a_200_252# w_0_0# VSUBS
X0 w_0_0# a_200_252# a_230_441# w_0_0# sky130_fd_pr__pfet_01v8 ad=0.1764 pd=1.54 as=0.1764 ps=1.54 w=1.26 l=0.15
X1 w_0_0# a_200_252# a_230_441# w_0_0# sky130_fd_pr__pfet_01v8 ad=0.1764 pd=1.54 as=0.1764 ps=1.54 w=1.26 l=0.15
X2 a_230_441# a_200_252# w_0_0# w_0_0# sky130_fd_pr__pfet_01v8 ad=0.1764 pd=1.54 as=0.1764 ps=1.54 w=1.26 l=0.15
X3 a_230_441# a_200_252# w_0_0# w_0_0# sky130_fd_pr__pfet_01v8 ad=0.1764 pd=1.54 as=0.1764 ps=1.54 w=1.26 l=0.15
X4 a_230_441# a_200_252# w_0_0# w_0_0# sky130_fd_pr__pfet_01v8 ad=0.1764 pd=1.54 as=0.1764 ps=1.54 w=1.26 l=0.15
X5 w_0_0# a_200_252# a_230_441# w_0_0# sky130_fd_pr__pfet_01v8 ad=0.3339 pd=3.05 as=0.1764 ps=1.54 w=1.26 l=0.15
X6 w_0_0# a_200_252# a_230_441# w_0_0# sky130_fd_pr__pfet_01v8 ad=0.1764 pd=1.54 as=0.1764 ps=1.54 w=1.26 l=0.15
X7 w_0_0# a_200_252# a_230_441# w_0_0# sky130_fd_pr__pfet_01v8 ad=0.1764 pd=1.54 as=0.1764 ps=1.54 w=1.26 l=0.15
X8 a_230_441# a_200_252# w_0_0# w_0_0# sky130_fd_pr__pfet_01v8 ad=0.1764 pd=1.54 as=0.1764 ps=1.54 w=1.26 l=0.15
X9 a_230_441# a_200_252# w_0_0# w_0_0# sky130_fd_pr__pfet_01v8 ad=0.1764 pd=1.54 as=0.1764 ps=1.54 w=1.26 l=0.15
X10 w_0_0# a_200_252# a_230_441# w_0_0# sky130_fd_pr__pfet_01v8 ad=0.1764 pd=1.54 as=0.1764 ps=1.54 w=1.26 l=0.15
X11 a_230_441# a_200_252# w_0_0# w_0_0# sky130_fd_pr__pfet_01v8 ad=0.1764 pd=1.54 as=0.3339 ps=3.05 w=1.26 l=0.15
C0 a_230_441# a_200_252# 0.538779f
C1 w_0_0# a_200_252# 2.98076f
C2 w_0_0# a_230_441# 4.47515f
C3 a_230_441# VSUBS 0.244237f
C4 a_200_252# VSUBS 0.377589f
C5 w_0_0# VSUBS 6.60734f
.ends

.subckt FIVE_TRANSISTOR_OTA_0 IB VOUT VIP VIN VSS VDD
XDCL_PMOS_S_13688038_X6_Y1_1774869037_0 li_1437_571# VDD VSS DCL_PMOS_S_13688038_X6_Y1_1774869037
XSCM_NMOS_16984956_X6_Y1_1774869040_0 m1_2376_1316# IB VSS SCM_NMOS_16984956_X6_Y1_1774869040
XNMOS_4T_73049722_X9_Y1_1774869038_0 VOUT VIN m1_2376_1316# VSS NMOS_4T_73049722_X9_Y1_1774869038
XNMOS_4T_73049722_X9_Y1_1774869038_1 li_1437_571# VIP m1_2376_1316# VSS NMOS_4T_73049722_X9_Y1_1774869038
XPMOS_S_86315193_X6_Y1_1774869039_0 VOUT li_1437_571# VDD VSS PMOS_S_86315193_X6_Y1_1774869039
R0 li_1437_571.n8 li_1437_571.t35 573.581
R1 li_1437_571.n6 li_1437_571.t24 573.581
R2 li_1437_571.n13 li_1437_571.t27 573.581
R3 li_1437_571.n11 li_1437_571.t30 573.581
R4 li_1437_571.n19 li_1437_571.t33 573.581
R5 li_1437_571.n17 li_1437_571.t25 573.581
R6 li_1437_571.n25 li_1437_571.t28 573.581
R7 li_1437_571.n23 li_1437_571.t31 573.581
R8 li_1437_571.n31 li_1437_571.t32 573.581
R9 li_1437_571.n29 li_1437_571.t34 573.581
R10 li_1437_571.n37 li_1437_571.t26 573.581
R11 li_1437_571.n35 li_1437_571.t29 573.581
R12 li_1437_571.n45 li_1437_571.t18 568.582
R13 li_1437_571.n45 li_1437_571.t12 568.582
R14 li_1437_571.n46 li_1437_571.t6 568.582
R15 li_1437_571.n46 li_1437_571.t2 568.582
R16 li_1437_571.n48 li_1437_571.t14 568.582
R17 li_1437_571.n48 li_1437_571.t8 568.582
R18 li_1437_571.n43 li_1437_571.t4 568.582
R19 li_1437_571.n43 li_1437_571.t20 568.582
R20 li_1437_571.n41 li_1437_571.t16 568.582
R21 li_1437_571.n41 li_1437_571.t10 568.582
R22 li_1437_571.n40 li_1437_571.t0 568.582
R23 li_1437_571.n40 li_1437_571.t22 568.582
R24 li_1437_571.n2 li_1437_571.n0 313.935
R25 li_1437_571.n57 li_1437_571.n56 313.935
R26 li_1437_571.n2 li_1437_571.n1 313.553
R27 li_1437_571.n4 li_1437_571.n3 313.553
R28 li_1437_571.n54 li_1437_571.n53 313.553
R29 li_1437_571.n56 li_1437_571.n55 313.553
R30 li_1437_571.n51 li_1437_571.n39 276.693
R31 li_1437_571.n15 li_1437_571.n9 161.685
R32 li_1437_571.n47 li_1437_571.n45 161.685
R33 li_1437_571.n42 li_1437_571.n40 161.685
R34 li_1437_571.n15 li_1437_571.n14 161.3
R35 li_1437_571.n21 li_1437_571.n20 161.3
R36 li_1437_571.n27 li_1437_571.n26 161.3
R37 li_1437_571.n33 li_1437_571.n32 161.3
R38 li_1437_571.n39 li_1437_571.n38 161.3
R39 li_1437_571.n47 li_1437_571.n46 161.3
R40 li_1437_571.n49 li_1437_571.n48 161.3
R41 li_1437_571.n44 li_1437_571.n43 161.3
R42 li_1437_571.n42 li_1437_571.n41 161.3
R43 li_1437_571.n8 li_1437_571.n7 33.7405
R44 li_1437_571.n6 li_1437_571.n5 33.7405
R45 li_1437_571.n13 li_1437_571.n12 33.7405
R46 li_1437_571.n11 li_1437_571.n10 33.7405
R47 li_1437_571.n19 li_1437_571.n18 33.7405
R48 li_1437_571.n17 li_1437_571.n16 33.7405
R49 li_1437_571.n25 li_1437_571.n24 33.7405
R50 li_1437_571.n23 li_1437_571.n22 33.7405
R51 li_1437_571.n31 li_1437_571.n30 33.7405
R52 li_1437_571.n29 li_1437_571.n28 33.7405
R53 li_1437_571.n37 li_1437_571.n36 33.7405
R54 li_1437_571.n35 li_1437_571.n34 33.7405
R55 li_1437_571.n9 li_1437_571.n6 24.9931
R56 li_1437_571.n9 li_1437_571.n8 24.9931
R57 li_1437_571.n14 li_1437_571.n11 24.9931
R58 li_1437_571.n14 li_1437_571.n13 24.9931
R59 li_1437_571.n20 li_1437_571.n17 24.9931
R60 li_1437_571.n20 li_1437_571.n19 24.9931
R61 li_1437_571.n26 li_1437_571.n23 24.9931
R62 li_1437_571.n26 li_1437_571.n25 24.9931
R63 li_1437_571.n32 li_1437_571.n29 24.9931
R64 li_1437_571.n32 li_1437_571.n31 24.9931
R65 li_1437_571.n38 li_1437_571.n35 24.9931
R66 li_1437_571.n38 li_1437_571.n37 24.9931
R67 li_1437_571.n0 li_1437_571.t19 21.8894
R68 li_1437_571.n0 li_1437_571.t13 21.8894
R69 li_1437_571.n1 li_1437_571.t7 21.8894
R70 li_1437_571.n1 li_1437_571.t3 21.8894
R71 li_1437_571.n3 li_1437_571.t15 21.8894
R72 li_1437_571.n3 li_1437_571.t9 21.8894
R73 li_1437_571.n53 li_1437_571.t5 21.8894
R74 li_1437_571.n53 li_1437_571.t21 21.8894
R75 li_1437_571.n55 li_1437_571.t17 21.8894
R76 li_1437_571.n55 li_1437_571.t11 21.8894
R77 li_1437_571.n57 li_1437_571.t1 21.8894
R78 li_1437_571.t23 li_1437_571.n57 21.8894
R79 li_1437_571.n51 li_1437_571.n50 6.3755
R80 li_1437_571.n52 li_1437_571.n51 4.5005
R81 li_1437_571.n39 li_1437_571.n33 0.384429
R82 li_1437_571.n33 li_1437_571.n27 0.384429
R83 li_1437_571.n27 li_1437_571.n21 0.384429
R84 li_1437_571.n21 li_1437_571.n15 0.384429
R85 li_1437_571.n44 li_1437_571.n42 0.384429
R86 li_1437_571.n49 li_1437_571.n47 0.384429
R87 li_1437_571.n56 li_1437_571.n54 0.384429
R88 li_1437_571.n4 li_1437_571.n2 0.384429
R89 li_1437_571.n50 li_1437_571.n44 0.192464
R90 li_1437_571.n50 li_1437_571.n49 0.192464
R91 li_1437_571.n54 li_1437_571.n52 0.192464
R92 li_1437_571.n52 li_1437_571.n4 0.192464
R93 VDD.n2 VDD.n0 379.685
R94 VDD.n13 VDD.n9 379.685
R95 VDD.n5 VDD.n0 379.3
R96 VDD.n21 VDD.n8 379.3
R97 VDD.n20 VDD.n19 379.3
R98 VDD.n16 VDD.n9 379.3
R99 VDD.n4 VDD.n3 54.0349
R100 VDD.n7 VDD.n6 54.0349
R101 VDD.n11 VDD.n10 54.0349
R102 VDD.n18 VDD.n17 54.0349
R103 VDD.n15 VDD.n14 54.0349
R104 VDD.n2 VDD.n1 27.0177
R105 VDD.n3 VDD.n2 27.0177
R106 VDD.n5 VDD.n4 27.0177
R107 VDD.n6 VDD.n5 27.0177
R108 VDD.n8 VDD.n7 27.0177
R109 VDD.n10 VDD.n8 27.0177
R110 VDD.n19 VDD.n11 27.0177
R111 VDD.n19 VDD.n18 27.0177
R112 VDD.n17 VDD.n16 27.0177
R113 VDD.n16 VDD.n15 27.0177
R114 VDD.n14 VDD.n13 27.0177
R115 VDD.n13 VDD.n12 27.0177
R116 VDD.n22 VDD.n21 18.5385
R117 VDD.n22 VDD 12.8837
R118 VDD VDD.n22 3.71423
R119 VDD.n21 VDD.n0 0.384429
R120 VDD.n21 VDD.n20 0.384429
R121 VDD.n20 VDD.n9 0.384429
R122 IB.n26 IB.t20 573.581
R123 IB.n24 IB.t18 573.581
R124 IB.n31 IB.t29 573.581
R125 IB.n29 IB.t33 573.581
R126 IB.n37 IB.t35 573.581
R127 IB.n35 IB.t26 573.581
R128 IB.n43 IB.t12 573.581
R129 IB.n41 IB.t6 573.581
R130 IB.n46 IB.t22 568.582
R131 IB.n46 IB.t4 568.582
R132 IB.n22 IB.t30 568.582
R133 IB.n22 IB.t27 568.582
R134 IB.n20 IB.t24 568.582
R135 IB.n20 IB.t34 568.582
R136 IB.n18 IB.t14 568.582
R137 IB.n18 IB.t16 568.582
R138 IB.n16 IB.t2 568.582
R139 IB.n16 IB.t10 568.582
R140 IB.n14 IB.t28 568.582
R141 IB.n14 IB.t25 568.582
R142 IB.n12 IB.t32 568.582
R143 IB.n12 IB.t31 568.582
R144 IB.n11 IB.t0 568.582
R145 IB.n11 IB.t8 568.582
R146 IB.n2 IB.n0 180.853
R147 IB.n7 IB.n5 180.852
R148 IB.n7 IB.n6 179.702
R149 IB.n9 IB.n8 179.702
R150 IB.n4 IB.n3 179.702
R151 IB.n2 IB.n1 179.702
R152 IB.n33 IB.n27 161.685
R153 IB.n13 IB.n11 161.685
R154 IB.n33 IB.n32 161.3
R155 IB.n39 IB.n38 161.3
R156 IB.n45 IB.n44 161.3
R157 IB.n47 IB.n46 161.3
R158 IB.n48 IB.n22 161.3
R159 IB.n21 IB.n20 161.3
R160 IB.n19 IB.n18 161.3
R161 IB.n17 IB.n16 161.3
R162 IB.n15 IB.n14 161.3
R163 IB.n13 IB.n12 161.3
R164 IB.n26 IB.n25 33.7405
R165 IB.n24 IB.n23 33.7405
R166 IB.n31 IB.n30 33.7405
R167 IB.n29 IB.n28 33.7405
R168 IB.n37 IB.n36 33.7405
R169 IB.n35 IB.n34 33.7405
R170 IB.n43 IB.n42 33.7405
R171 IB.n41 IB.n40 33.7405
R172 IB.n27 IB.n24 24.9931
R173 IB.n27 IB.n26 24.9931
R174 IB.n32 IB.n29 24.9931
R175 IB.n32 IB.n31 24.9931
R176 IB.n38 IB.n35 24.9931
R177 IB.n38 IB.n37 24.9931
R178 IB.n44 IB.n41 24.9931
R179 IB.n44 IB.n43 24.9931
R180 IB.n5 IB.t19 13.3338
R181 IB.n5 IB.t21 13.3338
R182 IB.n6 IB.t7 13.3338
R183 IB.n6 IB.t13 13.3338
R184 IB.n8 IB.t23 13.3338
R185 IB.n8 IB.t5 13.3338
R186 IB.n3 IB.t15 13.3338
R187 IB.n3 IB.t17 13.3338
R188 IB.n1 IB.t3 13.3338
R189 IB.n1 IB.t11 13.3338
R190 IB.n0 IB.t1 13.3338
R191 IB.n0 IB.t9 13.3338
R192 IB IB.n10 5.438
R193 IB IB.n48 5.438
R194 IB.n10 IB.n4 0.768357
R195 IB.n15 IB.n13 0.384429
R196 IB.n17 IB.n15 0.384429
R197 IB.n19 IB.n17 0.384429
R198 IB.n21 IB.n19 0.384429
R199 IB.n48 IB.n21 0.384429
R200 IB.n48 IB.n47 0.384429
R201 IB.n47 IB.n45 0.384429
R202 IB.n45 IB.n39 0.384429
R203 IB.n39 IB.n33 0.384429
R204 IB.n4 IB.n2 0.384429
R205 IB.n10 IB.n9 0.384429
R206 IB.n9 IB.n7 0.384429
R207 VSS.n35 VSS.n34 112872
R208 VSS.n28 VSS.n26 1179.68
R209 VSS.n19 VSS.n9 1179.68
R210 VSS.n30 VSS.n3 1179.3
R211 VSS.n2 VSS.n1 1179.3
R212 VSS.n36 VSS.n35 1179.3
R213 VSS.n14 VSS.n13 1179.3
R214 VSS.n15 VSS.n9 1179.3
R215 VSS.n18 VSS.n16 1179.3
R216 VSS.n21 VSS.n7 1179.3
R217 VSS.n26 VSS.n25 1179.3
R218 VSS.n19 VSS.n18 1179.3
R219 VSS.n21 VSS.n20 1179.3
R220 VSS.n25 VSS.n5 1179.3
R221 VSS.n29 VSS.n28 1179.3
R222 VSS.n32 VSS.n31 1179.3
R223 VSS.n13 VSS.n12 510.767
R224 VSS.n3 VSS.n2 510.661
R225 VSS.n35 VSS.n2 510.661
R226 VSS.n12 VSS.n0 272.411
R227 VSS.n34 VSS.n3 255.332
R228 VSS.n13 VSS.n9 243.189
R229 VSS.n10 VSS.n9 182.392
R230 VSS.n12 VSS.n11 144.946
R231 VSS.n17 VSS.n8 121.594
R232 VSS.n23 VSS.n22 121.594
R233 VSS.n24 VSS.n6 121.594
R234 VSS.n27 VSS.n4 121.594
R235 VSS.n18 VSS.n10 60.7974
R236 VSS.n18 VSS.n17 60.7974
R237 VSS.n21 VSS.n8 60.7974
R238 VSS.n22 VSS.n21 60.7974
R239 VSS.n25 VSS.n23 60.7974
R240 VSS.n25 VSS.n24 60.7974
R241 VSS.n28 VSS.n6 60.7974
R242 VSS.n28 VSS.n27 60.7974
R243 VSS.n32 VSS.n4 60.7974
R244 VSS.n33 VSS.n32 60.7974
R245 VSS.n34 VSS.n33 60.7974
R246 VSS.n37 VSS.n36 10.7657
R247 VSS.n11 VSS 7.5005
R248 VSS VSS.n0 3.973
R249 VSS VSS.n37 3.58615
R250 VSS.n14 VSS.n11 0.384429
R251 VSS.n15 VSS.n14 0.384429
R252 VSS.n16 VSS.n15 0.384429
R253 VSS.n16 VSS.n7 0.384429
R254 VSS.n26 VSS.n7 0.384429
R255 VSS.n20 VSS.n19 0.384429
R256 VSS.n20 VSS.n5 0.384429
R257 VSS.n29 VSS.n5 0.384429
R258 VSS.n31 VSS.n29 0.384429
R259 VSS.n31 VSS.n30 0.384429
R260 VSS.n30 VSS.n1 0.384429
R261 VSS.n36 VSS.n1 0.384429
R262 VSS.n37 VSS.n0 0.0880375
R263 VIN.n8 VIN.t16 568.582
R264 VIN.n8 VIN.t11 568.582
R265 VIN.n9 VIN.t7 568.582
R266 VIN.n9 VIN.t6 568.582
R267 VIN.n11 VIN.t1 568.582
R268 VIN.n11 VIN.t15 568.582
R269 VIN.n13 VIN.t10 568.582
R270 VIN.n13 VIN.t5 568.582
R271 VIN.n7 VIN.t0 568.582
R272 VIN.n7 VIN.t14 568.582
R273 VIN.n5 VIN.t13 568.582
R274 VIN.n5 VIN.t9 568.582
R275 VIN.n3 VIN.t4 568.582
R276 VIN.n3 VIN.t17 568.582
R277 VIN.n1 VIN.t12 568.582
R278 VIN.n1 VIN.t8 568.582
R279 VIN.n0 VIN.t3 568.582
R280 VIN.n0 VIN.t2 568.582
R281 VIN.n10 VIN.n8 161.685
R282 VIN.n2 VIN.n0 161.685
R283 VIN.n10 VIN.n9 161.3
R284 VIN.n12 VIN.n11 161.3
R285 VIN.n14 VIN.n13 161.3
R286 VIN VIN.n7 161.3
R287 VIN.n6 VIN.n5 161.3
R288 VIN.n4 VIN.n3 161.3
R289 VIN.n2 VIN.n1 161.3
R290 VIN.n4 VIN.n2 0.384429
R291 VIN.n6 VIN.n4 0.384429
R292 VIN VIN.n6 0.384429
R293 VIN VIN.n14 0.384429
R294 VIN.n14 VIN.n12 0.384429
R295 VIN.n12 VIN.n10 0.384429
R296 VIP.n8 VIP.t2 568.582
R297 VIP.n8 VIP.t3 568.582
R298 VIP.n9 VIP.t8 568.582
R299 VIP.n9 VIP.t12 568.582
R300 VIP.n11 VIP.t17 568.582
R301 VIP.n11 VIP.t4 568.582
R302 VIP.n13 VIP.t9 568.582
R303 VIP.n13 VIP.t13 568.582
R304 VIP.n7 VIP.t14 568.582
R305 VIP.n7 VIP.t0 568.582
R306 VIP.n5 VIP.t5 568.582
R307 VIP.n5 VIP.t10 568.582
R308 VIP.n3 VIP.t15 568.582
R309 VIP.n3 VIP.t1 568.582
R310 VIP.n1 VIP.t6 568.582
R311 VIP.n1 VIP.t7 568.582
R312 VIP.n0 VIP.t11 568.582
R313 VIP.n0 VIP.t16 568.582
R314 VIP.n10 VIP.n8 161.685
R315 VIP.n2 VIP.n0 161.685
R316 VIP.n10 VIP.n9 161.3
R317 VIP.n12 VIP.n11 161.3
R318 VIP.n14 VIP.n13 161.3
R319 VIP VIP.n7 161.3
R320 VIP.n6 VIP.n5 161.3
R321 VIP.n4 VIP.n3 161.3
R322 VIP.n2 VIP.n1 161.3
R323 VIP.n4 VIP.n2 0.384429
R324 VIP.n6 VIP.n4 0.384429
R325 VIP VIP.n6 0.384429
R326 VIP VIP.n14 0.384429
R327 VIP.n14 VIP.n12 0.384429
R328 VIP.n12 VIP.n10 0.384429
C0 VOUT VDD 0.113509f
C1 m1_2376_1316# VOUT 0.071619f
C2 IB VIN 0.011228f
C3 IB VDD 0.198676f
C4 IB m1_2376_1316# 0.10766f
C5 VIN VDD 0.009275f
C6 VIN m1_2376_1316# 0.001763f
C7 IB VIP 0.011228f
C8 VIP VIN 0.034325f
C9 m1_2376_1316# VDD 0.11081f
C10 IB VOUT 0.033587f
C11 VIP VDD 0.009825f
C12 VIP m1_2376_1316# 0.001763f
C13 VIN VOUT 0.001335f
C14 VDD.n0 VSS 0.076179f
C15 VDD.n1 VSS 0.951986f
C16 VDD.n2 VSS 0.163396f
C17 VDD.n3 VSS 0.259633f
C18 VDD.n4 VSS 0.259633f
C19 VDD.n5 VSS 0.163361f
C20 VDD.n6 VSS 0.259633f
C21 VDD.n7 VSS 0.259633f
C22 VDD.n8 VSS 0.163361f
C23 VDD.n9 VSS 0.076179f
C24 VDD.n10 VSS 0.259633f
C25 VDD.n11 VSS 0.259633f
C26 VDD.n12 VSS 0.951986f
C27 VDD.n13 VSS 0.163396f
C28 VDD.n14 VSS 0.259633f
C29 VDD.n15 VSS 0.259633f
C30 VDD.n16 VSS 0.163361f
C31 VDD.n17 VSS 0.259633f
C32 VDD.n18 VSS 0.259633f
C33 VDD.n19 VSS 0.163361f
C34 VDD.n20 VSS 0.041983f
C35 VDD.n21 VSS 1.01739f
C36 VDD.n22 VSS 1.24681f
C37 li_1437_571.t1 VSS 0.039144f
C38 li_1437_571.t19 VSS 0.039144f
C39 li_1437_571.t13 VSS 0.039144f
C40 li_1437_571.n0 VSS 0.184865f
C41 li_1437_571.t7 VSS 0.039144f
C42 li_1437_571.t3 VSS 0.039144f
C43 li_1437_571.n1 VSS 0.184424f
C44 li_1437_571.n2 VSS 0.75205f
C45 li_1437_571.t15 VSS 0.039144f
C46 li_1437_571.t9 VSS 0.039144f
C47 li_1437_571.n3 VSS 0.184424f
C48 li_1437_571.n4 VSS 0.365683f
C49 li_1437_571.t24 VSS 0.038445f
C50 li_1437_571.n5 VSS 0.045435f
C51 li_1437_571.n6 VSS 0.071299f
C52 li_1437_571.t35 VSS 0.038445f
C53 li_1437_571.n7 VSS 0.045435f
C54 li_1437_571.n8 VSS 0.071299f
C55 li_1437_571.n9 VSS 0.023665f
C56 li_1437_571.t30 VSS 0.038445f
C57 li_1437_571.n10 VSS 0.045435f
C58 li_1437_571.n11 VSS 0.071299f
C59 li_1437_571.t27 VSS 0.038445f
C60 li_1437_571.n12 VSS 0.045435f
C61 li_1437_571.n13 VSS 0.071299f
C62 li_1437_571.n14 VSS 0.023237f
C63 li_1437_571.n15 VSS 0.392207f
C64 li_1437_571.t25 VSS 0.038445f
C65 li_1437_571.n16 VSS 0.045435f
C66 li_1437_571.n17 VSS 0.071299f
C67 li_1437_571.t33 VSS 0.038445f
C68 li_1437_571.n18 VSS 0.045435f
C69 li_1437_571.n19 VSS 0.071299f
C70 li_1437_571.n20 VSS 0.023237f
C71 li_1437_571.n21 VSS 0.212472f
C72 li_1437_571.t31 VSS 0.038445f
C73 li_1437_571.n22 VSS 0.045435f
C74 li_1437_571.n23 VSS 0.071299f
C75 li_1437_571.t28 VSS 0.038445f
C76 li_1437_571.n24 VSS 0.045435f
C77 li_1437_571.n25 VSS 0.071299f
C78 li_1437_571.n26 VSS 0.023237f
C79 li_1437_571.n27 VSS 0.212472f
C80 li_1437_571.t34 VSS 0.038445f
C81 li_1437_571.n28 VSS 0.045435f
C82 li_1437_571.n29 VSS 0.071299f
C83 li_1437_571.t32 VSS 0.038445f
C84 li_1437_571.n30 VSS 0.045435f
C85 li_1437_571.n31 VSS 0.071299f
C86 li_1437_571.n32 VSS 0.023237f
C87 li_1437_571.n33 VSS 0.212472f
C88 li_1437_571.t29 VSS 0.038445f
C89 li_1437_571.n34 VSS 0.045435f
C90 li_1437_571.n35 VSS 0.071299f
C91 li_1437_571.t26 VSS 0.038445f
C92 li_1437_571.n36 VSS 0.045435f
C93 li_1437_571.n37 VSS 0.071299f
C94 li_1437_571.n38 VSS 0.023237f
C95 li_1437_571.n39 VSS 0.895456f
C96 li_1437_571.t0 VSS 0.039135f
C97 li_1437_571.t22 VSS 0.039135f
C98 li_1437_571.n40 VSS 0.175867f
C99 li_1437_571.t16 VSS 0.039135f
C100 li_1437_571.t10 VSS 0.039135f
C101 li_1437_571.n41 VSS 0.175439f
C102 li_1437_571.n42 VSS 0.392207f
C103 li_1437_571.t4 VSS 0.039135f
C104 li_1437_571.t20 VSS 0.039135f
C105 li_1437_571.n43 VSS 0.175439f
C106 li_1437_571.n44 VSS 0.185755f
C107 li_1437_571.t18 VSS 0.039135f
C108 li_1437_571.t12 VSS 0.039135f
C109 li_1437_571.n45 VSS 0.175867f
C110 li_1437_571.t6 VSS 0.039135f
C111 li_1437_571.t2 VSS 0.039135f
C112 li_1437_571.n46 VSS 0.175439f
C113 li_1437_571.n47 VSS 0.392207f
C114 li_1437_571.t14 VSS 0.039135f
C115 li_1437_571.t8 VSS 0.039135f
C116 li_1437_571.n48 VSS 0.175439f
C117 li_1437_571.n49 VSS 0.185755f
C118 li_1437_571.n50 VSS 0.136037f
C119 li_1437_571.n51 VSS 7.59178f
C120 li_1437_571.n52 VSS 0.053435f
C121 li_1437_571.t5 VSS 0.039144f
C122 li_1437_571.t21 VSS 0.039144f
C123 li_1437_571.n53 VSS 0.184424f
C124 li_1437_571.n54 VSS 0.365683f
C125 li_1437_571.t17 VSS 0.039144f
C126 li_1437_571.t11 VSS 0.039144f
C127 li_1437_571.n55 VSS 0.184424f
C128 li_1437_571.n56 VSS 0.75205f
C129 li_1437_571.n57 VSS 0.184865f
C130 li_1437_571.t23 VSS 0.039144f
C131 VDD VSS 25.231585f
C132 VIP VSS 4.085238f
C133 VOUT VSS 11.866503f
C134 m1_2376_1316# VSS 7.506139f
C135 VIN VSS 4.111702f
C136 IB VSS 11.152805f
.ends
